** sch_path: /home/bah67de/git/heichips26_dram_replica/macros/heichips26_dram_replica/macros/inverter/testbenches/xschem/inverter_tb_dc_vout.sch
**.subckt inverter_tb_dc_vout
VDD VDD GND {VDD}
C1 vout GND {Cload}
Vgsp vin GND 0
x1 VDD vin vout GND inverter
**** begin user architecture code

.include ../../../netlist/pex/inverter_magic_pex_3.spice
.param VDD=1.5
.csparam VDD=VDD
.param Vcm=VDD/2
.csparam Vcm=Vcm
.param temp=27
.param Cload=10p
.param Rload=1k
.options savecurrents klu method=gear reltol=1e-3 abstol=1e-15 gmin=1e-15
.control

save all

* Operating Point Analysis
op
remzerovec
write inverter_tb_dc_vout.raw
set appendwrite

* DC Sweep
dc Vgsp 0 $&VDD 1m
remzerovec
write inverter_tb_dc_vout.raw
set appendwrite

* Plotting
plot vin vout

* Measurement
meas dc Vgsp_at_Vcm when vout=Vcm
print Vgsp_at_Vcm

* Write Data
unset appendwrite
set wr_vecnames
set wr_singlescale
wrdata ../plot_simulations/data/inverter_tb_dc_vout.txt v(vin) v(vout)

*quit
.endc

.lib cornerMOSlv.lib mos_tt
.lib cornerMOShv.lib mos_tt
.lib cornerRES.lib res_typ
.lib cornerDIO.lib dio_tt

**** end user architecture code
**.ends

* expanding   symbol:  inverter.sym # of pins=4
** sym_path: /home/bah67de/git/heichips26_dram_replica/macros/heichips26_dram_replica/macros/inverter/schematic/xschem/inverter.sym
** sch_path: /home/bah67de/git/heichips26_dram_replica/macros/heichips26_dram_replica/macros/inverter/schematic/xschem/inverter.sch
.subckt inverter VDD vin vout VSS
*.ipin vin
*.iopin VDD
*.iopin VSS
*.iopin vout
XMdummy1 VSS VSS VSS VSS sg13_lv_nmos w=2.0u l=1.0u ng=2 m=1 mm_ok=1
XMdummy2 VDD VDD VDD VDD sg13_lv_pmos w=12.0u l=1.0u ng=2 m=1 mm_ok=1
XM1 vout vin VSS VSS sg13_lv_nmos w=20.0u l=1.0u ng=20 m=1 mm_ok=1
XM2 vout vin VDD VDD sg13_lv_pmos w=120.0u l=1.0u ng=20 m=1 mm_ok=1
.ends

.GLOBAL GND
.GLOBAL VDD
.end
