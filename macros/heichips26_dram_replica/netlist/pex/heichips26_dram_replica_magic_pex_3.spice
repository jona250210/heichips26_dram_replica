* PEX produced on Tue Sep 15 00:13:16 CEST 2026 using scripts/sak-pex.sh with m=3 and s=1 (extresist threshold=10000 mOhm, minres=1000 mOhm, mindelay=1 ps)
* NGSPICE file created from heichips26_dram_replica_pex.ext - technology: ihp-sg13cmos5l

.subckt heichips26_dram_replica_pex VPWR VAPWR VGND rst_n clk ena uio_in[7]
+ uio_in[6] uio_in[5] uio_in[4] uio_in[3] uio_in[2] uio_in[1] uio_in[0] ui_in[7]
+ ui_in[6] ui_in[5] ui_in[4] ui_in[3] ui_in[2] ui_in[1] ui_in[0] uio_oe[7]
+ uio_oe[6] uio_oe[5] uio_oe[4] uio_oe[3] uio_oe[2] uio_oe[1] uio_oe[0]
+ uio_out[7] uio_out[6] uio_out[5] uio_out[4] uio_out[3] uio_out[2] uio_out[1]
+ uio_out[0] uo_out[7] uo_out[6] uo_out[5] uo_out[4] uo_out[3] uo_out[2]
+ uo_out[1] uo_out[0]
X0 a_1790_1879# ui_in[2] VGND.t3 VGND.t2 sg13_lv_nmos ad=0.1005p pd=1.34u as=0.1005p ps=1.34u w=0.15u l=0.13u
X1 a_2816_1865# ui_in[1] a_2098_1879# VGND.t15 sg13_lv_nmos ad=0.102p pd=1.28u as=0.102p ps=1.28u w=0.3u l=0.13u
X2 uo_out[0] a_3132_1864# VGND.t11 VGND.t10 sg13_lv_nmos ad=0.1005p pd=1.34u as=0.1005p ps=1.34u w=0.15u l=0.13u
X3 a_3132_1864# ui_in[2] a_3030_1864# VGND.t5 sg13_lv_nmos ad=57f pd=0.68u as=57f ps=0.68u w=0.3u l=0.13u
X4 a_2098_1879# ui_in[2] uo_out[0] VGND.t4 sg13_lv_nmos ad=0.1005p pd=1.34u as=0.1005p ps=1.34u w=0.15u l=0.13u
X5 a_2098_1879# ui_in[2] ui_in[0] VPWR sg13_lv_pmos ad=0.1005p pd=1.34u as=0.1005p ps=1.34u w=0.15u l=0.13u
X6 VGND.t13 VPWR VGND.t13 VGND.t12 sg13_lv_pmos ad=3.4p pd=20.68u as=0 ps=0 w=10u l=10u
X7 a_3030_1864# ui_in[2] a_3132_1864# VGND.t6 sg13_lv_nmos ad=57f pd=0.68u as=57f ps=0.68u w=0.3u l=0.13u
X8 a_1790_1879# ui_in[2] VPWR VPWR sg13_lv_pmos ad=0.1005p pd=1.34u as=0.1005p ps=1.34u w=0.15u l=0.13u
X9 uo_out[0] a_3132_1864# VPWR VPWR sg13_lv_pmos ad=0.1005p pd=1.34u as=0.1005p ps=1.34u w=0.15u l=0.13u
X10 a_3132_1864# ui_in[3] VPWR VPWR sg13_lv_pmos ad=0.1005p pd=1.34u as=0.1005p ps=1.34u w=0.15u l=0.13u
X11 a_2098_1879# a_1790_1879# uo_out[0] VPWR sg13_lv_pmos ad=0.1005p pd=1.34u as=0.1005p ps=1.34u w=0.15u l=0.13u
X12 a_2098_1879# a_1790_1879# ui_in[0] VGND.t14 sg13_lv_nmos ad=0.1005p pd=1.34u as=0.1005p ps=1.34u w=0.15u l=0.13u
X13 a_3030_1864# a_2816_1865# VGND.t9 VGND.t8 sg13_lv_nmos ad=57f pd=0.68u as=0.102p ps=1.28u w=0.3u l=0.13u
X14 a_3132_1864# ui_in[2] a_3030_1864# VGND.t7 sg13_lv_nmos ad=0.102p pd=1.28u as=57f ps=0.68u w=0.3u l=0.13u
X15 VGND.t1 VAPWR VGND.t1 VGND.t0 sg13_lv_pmos ad=3.4p pd=20.68u as=0 ps=0 w=10u l=10u
R0 VGND.t2 VGND.t10 15238.2
R1 VGND.t14 VGND.t2 417.344
R2 VGND.t4 VGND.t14 417.344
R3 VGND.t10 VGND.n1 217.821
R4 VGND.t6 VGND.n2 15.9536
R5 VGND.t7 VGND.n1 24.4718
R6 VGND.n2 VGND.t5 67.0523
R7 VGND.n0 VGND.t8 17.4231
R8 VGND.t5 VGND.n0 38.4795
R9 VGND.n1 VGND.n2 1.75662
R10 VGND.n40 VGND.n1 17.0005
R11 VGND.n1 VGND.n39 17.0005
R12 VGND.n1 VGND.n33 17.0005
R13 VGND.n1 VGND.n38 17.0005
R14 VGND.n1 VGND.n34 17.0005
R15 VGND.n1 VGND.n37 17.0005
R16 VGND.n1 VGND.n35 17.0005
R17 VGND.n1 VGND.n36 17.0005
R18 VGND.n1 VGND.n3 0.807564
R19 VGND.n3 VGND.t3 0.510141
R20 VGND.t4 VGND.n1 217.819
R21 VGND.n43 VGND.n42 5.85477
R22 VGND.t3 VGND.n41 5.66717
R23 VGND.t3 VGND.n25 5.66717
R24 VGND.t3 VGND.n32 5.66717
R25 VGND.t3 VGND.n26 5.66717
R26 VGND.t3 VGND.n31 5.66717
R27 VGND.t3 VGND.n27 5.66717
R28 VGND.t3 VGND.n30 5.66717
R29 VGND.t3 VGND.n28 5.66717
R30 VGND.t3 VGND.n29 5.66717
R31 VGND.t3 VGND.t11 5.66466
R32 VGND.n10 VGND.t13 0.412831
R33 VGND.n1 VGND.n4 1.1471
R34 VGND.n8 VGND.t1 0.412464
R35 VGND.n6 VGND.n5 0.209311
R36 VGND.n12 VGND.n11 0.00335118
R37 VGND.n13 VGND.n6 0.204366
R38 VGND.n13 VGND.n14 0.00335935
R39 VGND.n9 VGND.n6 0.204366
R40 VGND.n23 VGND.n9 0.00335935
R41 VGND.n24 VGND.n5 0.00335118
R42 VGND.n11 VGND.n20 0.409591
R43 VGND.n21 VGND.n19 0.409591
R44 VGND.n14 VGND.n18 0.409591
R45 VGND.n22 VGND.n17 0.409591
R46 VGND.n23 VGND.n16 0.409591
R47 VGND.n24 VGND.n15 0.409591
R48 VGND.n5 VGND.n8 0.412459
R49 VGND.n42 VGND.t3 0.231269
R50 VGND.n7 VGND.n12 0.22079
R51 VGND.n43 VGND.n7 3.2145
R52 VGND.n7 VGND.n6 0.0119793
R53 VGND VGND.n43 0.132148
R54 VGND.t13 VGND.t12 0.775521
R55 VGND.t1 VGND.t0 0.65313
R56 VGND.n42 VGND 0.0298333
R57 VGND.n4 VGND.t11 0.019753
R58 VGND.n41 VGND.n4 0.011837
R59 VGND.t9 VGND.n3 0.0852424
R60 VGND.n36 VGND.n29 0.0112242
R61 VGND.n35 VGND.n28 0.0112242
R62 VGND.n37 VGND.n30 0.0112242
R63 VGND.n34 VGND.n27 0.0112242
R64 VGND.n38 VGND.n31 0.0112242
R65 VGND.n33 VGND.n26 0.0112242
R66 VGND.n39 VGND.n32 0.0112242
R67 VGND.n40 VGND.n25 0.0112242
R68 VGND.n36 VGND.n28 0.0106114
R69 VGND.n35 VGND.n30 0.0106114
R70 VGND.n37 VGND.n27 0.0106114
R71 VGND.n34 VGND.n31 0.0106114
R72 VGND.n38 VGND.n26 0.0106114
R73 VGND.n33 VGND.n32 0.0106114
R74 VGND.n39 VGND.n25 0.0106114
R75 VGND.n41 VGND.n40 0.0106114
R76 VGND.t9 VGND.n29 0.0106114
R77 VGND.n10 VGND.n20 0.00643258
R78 VGND.n20 VGND.n19 0.00643258
R79 VGND.n19 VGND.n18 0.00643258
R80 VGND.n18 VGND.n17 0.00643258
R81 VGND.n17 VGND.n16 0.00643258
R82 VGND.n16 VGND.n15 0.00643258
R83 VGND.n15 VGND.n8 0.00643258
R84 VGND.n12 VGND.n10 0.412459
R85 VGND.n21 VGND.n11 0.00524607
R86 VGND.n13 VGND.n21 0.00335935
R87 VGND.n22 VGND.n14 0.00524607
R88 VGND.n9 VGND.n22 0.00335935
R89 VGND.n24 VGND.n23 0.00524607
R90 VGND.n1 VGND.t15 24.0404
R91 VGND.n1 VGND.n0 1.25149
C0 ui_in[2] a_1790_1879# 0.45597f
C1 a_3132_1864# a_3030_1864# 0.28368f
C2 VPWR uo_out[0] 1.11671f
C3 ui_in[1] VPWR 0.01413f
C4 uo_out[0] a_2098_1879# 0.34131f
C5 ui_in[1] a_2098_1879# 0.51602f
C6 ui_in[2] ui_in[3] 6.01058f
C7 VPWR a_1790_1879# 0.21003f
C8 ui_in[2] a_2816_1865# 0.05334f
C9 a_1790_1879# a_2098_1879# 0.36549f
C10 uo_out[0] a_3132_1864# 0.15712f
C11 ui_in[2] ui_in[0] 0.1152f
C12 VPWR ui_in[3] 0.61725f
C13 a_1790_1879# a_3132_1864# 0.01229f
C14 ui_in[3] a_2098_1879# 0.02044f
C15 a_2816_1865# a_2098_1879# 0.05039f
C16 ui_in[1] uo_out[0] 0.06036f
C17 uio_oe[7] ui_in[0] 0.01618f
C18 ui_in[3] a_3030_1864# 0.01433f
C19 VPWR ui_in[0] 0.04984f
C20 ui_in[0] a_2098_1879# 0.29526f
C21 ui_in[3] a_3132_1864# 0.03739f
C22 uo_out[0] a_1790_1879# 0.39457f
C23 ui_in[2] VPWR 0.24973f
C24 ui_in[2] a_2098_1879# 0.0857f
C25 ui_in[2] a_3030_1864# 0.06885f
C26 uo_out[0] ui_in[3] 0.30695f
C27 ui_in[1] ui_in[3] 0.06418f
C28 ui_in[2] a_3132_1864# 0.1002f
C29 VPWR a_2098_1879# 0.16107f
C30 ui_in[1] a_2816_1865# 0.02115f
C31 ui_in[3] a_1790_1879# 0.01326f
C32 uo_out[0] ui_in[0] 0.06382f
C33 ui_in[1] ui_in[0] 9.73224f
C34 VPWR a_3030_1864# 0.02093f
C35 a_3030_1864# a_2098_1879# 0.01254f
C36 ui_in[2] uo_out[0] 0.82182f
C37 VPWR a_3132_1864# 0.37245f
C38 ui_in[2] ui_in[1] 7.08533f
C39 ui_in[0] a_1790_1879# 0.14151f
C40 uo_out[1] VGND 0.02995f
C41 uo_out[2] VGND 0.02995f
C42 uo_out[3] VGND 0.02995f
C43 uo_out[4] VGND 0.02995f
C44 uo_out[5] VGND 0.02995f
C45 uo_out[6] VGND 0.02995f
C46 uo_out[7] VGND 0.02995f
C47 uio_out[0] VGND 0.02995f
C48 uio_out[1] VGND 0.02995f
C49 uio_out[2] VGND 0.02995f
C50 uio_out[3] VGND 0.02995f
C51 uio_out[4] VGND 0.02995f
C52 uio_out[5] VGND 0.02995f
C53 uio_out[6] VGND 0.02995f
C54 uio_out[7] VGND 0.02995f
C55 uio_oe[0] VGND 0.02995f
C56 uio_oe[1] VGND 0.02995f
C57 uio_oe[2] VGND 0.02995f
C58 uio_oe[3] VGND 0.02995f
C59 uio_oe[4] VGND 0.02995f
C60 uio_oe[5] VGND 0.02995f
C61 uio_oe[6] VGND 0.02995f
C62 uio_oe[7] VGND 0.02995f
C63 ui_in[4] VGND 0.03799f
C64 ui_in[5] VGND 0.03799f
C65 ui_in[6] VGND 0.03799f
C66 ui_in[7] VGND 0.03799f
C67 uio_in[0] VGND 0.03799f
C68 uio_in[1] VGND 0.03799f
C69 uio_in[2] VGND 0.03799f
C70 uio_in[3] VGND 0.03799f
C71 uio_in[4] VGND 0.03799f
C72 uio_in[5] VGND 0.03799f
C73 uio_in[6] VGND 0.03799f
C74 uio_in[7] VGND 0.03799f
C75 ena VGND 0.03799f
C76 clk VGND 0.03799f
C77 rst_n VGND 0.04448f
C78 uo_out[0] VGND 2.4659f
C79 ui_in[0] VGND 4.44618f
C80 VPWR VGND 2.67042f
C81 a_3030_1864# VGND 0.89837f
C82 a_3132_1864# VGND 2.67042f
C83 a_2098_1879# VGND 2.64582f
C84 VGND.t3 VGND 1.5324f
C85 VGND.t1 VGND 50.6067f
C86 VGND.t13 VGND 60.1305f
C87 VGND.t11 VGND 0.43619f
C88 VGND.t9 VGND 0.70826f
.ends
