* PEX produced on Wed Aug 19 19:26:10 CEST 2026 using scripts/sak-pex.sh with m=3 and s=1 (extresist threshold=10000 mOhm, minres=1000 mOhm, mindelay=1 ps)
* NGSPICE file created from dramcell_2_0_pex.ext - technology: ihp-sg13cmos5l

.subckt dramcell_2_0_pex WWL WBL RWL RBL VGND NodeC
X0 a_208_0# NodeC VGND VGND.t1 sg13_lv_nmos ad=57f pd=0.68u as=0.102p ps=1.28u w=0.3u l=0.13u
X1 NodeC WWL WBL VGND.t0 sg13_lv_nmos ad=0.102p pd=1.28u as=0.102p ps=1.28u w=0.3u l=0.13u
X2 a_208_0# RWL RBL VGND.t3 sg13_lv_nmos ad=57f pd=0.68u as=57f ps=0.68u w=0.3u l=0.13u
X3 RBL RWL a_208_0# VGND.t2 sg13_lv_nmos ad=57f pd=0.68u as=57f ps=0.68u w=0.3u l=0.13u
X4 RBL RWL a_208_0# VGND.t4 sg13_lv_nmos ad=0.102p pd=1.28u as=57f ps=0.68u w=0.3u l=0.13u
R0 VGND.n4 VGND.t1 198.838
R1 VGND.t3 VGND.n0 198.838
R2 VGND.t0 VGND 172.168
R3 VGND.t2 VGND.n0 156.977
R4 VGND.n5 VGND.t2 80.2331
R5 VGND.t4 VGND.n1 80.2331
R6 VGND.n7 VGND.t0 73.2563
R7 VGND.t1 VGND.n2 38.3726
R8 VGND.n6 VGND.t3 38.3726
R9 VGND.n8 VGND.n3 29.7391
R10 VGND VGND.n1 17.0005
R11 VGND VGND.n6 17.0005
R12 VGND VGND.n0 17.0005
R13 VGND VGND.n5 17.0005
R14 VGND VGND.n2 17.0005
R15 VGND VGND.n4 17.0005
R16 VGND VGND.n7 17.0005
R17 VGND VGND.n0 17.0005
R18 VGND.n7 VGND.n3 14.8698
R19 VGND.n9 VGND.n2 14.8698
R20 VGND.n10 VGND.n6 14.8698
R21 VGND.n8 VGND.n4 14.8698
R22 VGND.n9 VGND.n5 14.8698
R23 VGND.n10 VGND.n1 14.8698
R24 VGND.t4 VGND 165.192
R25 VGND VGND.n3 1.0666
R26 VGND VGND.n8 1.0666
R27 VGND VGND.n9 1.0666
R28 VGND VGND.n10 1.0666
C0 WWL NodeC 0.02078f
C1 NodeC RWL 0.0394f
C2 RBL a_208_0# 0.2209f
C3 NodeC a_208_0# 0.03327f
C4 NodeC WBL 0.03906f
C5 a_208_0# RWL 0.05336f
C6 RBL RWL 0.05966f
C7 RBL VGND 0.37685f
C8 NodeC VGND 0.10317f
C9 a_208_0# VGND 0.52727f
C10 WBL VGND 0.16894f
.ends
