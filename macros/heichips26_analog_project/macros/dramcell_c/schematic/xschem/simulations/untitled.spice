** sch_path: /home/bah67de/git/heichips26_dram_replica/macros/heichips26_analog_project/macros/dramcell_2_0/schematic/xschem/untitled.sch
**.subckt untitled RBL WWL WBL RWL VGND NodeC VPWR PreCh
*.opin RBL
*.ipin WWL
*.ipin WBL
*.ipin RWL
*.iopin VGND
*.iopin NodeC
*.iopin VPWR
*.ipin PreCh
XM4 CWBL WWL NodeC VGND sg13_lv_nmos w=0.3u l=0.13u ng=1 m=1 mm_ok=1
XM5 net1 NodeC VGND VGND sg13_lv_nmos w=0.3u l=0.13u ng=1 m=1 mm_ok=1
XM6 ~RBL RWL net1 VGND sg13_lv_nmos w=0.9u l=0.13u ng=3 m=1 mm_ok=1
XM2 ~RBL PreCh VPWR VPWR sg13_lv_pmos w=0.15u l=0.13u ng=1 m=1 mm_ok=1
XM1 CWBL RWL WBL VPWR sg13_lv_pmos w=0.15u l=0.13u ng=1 m=1 mm_ok=1
XM7 WBL ~ReFr CWBL GND sg13_lv_nmos w=0.15u l=0.13u ng=1 m=1 mm_ok=1
XM3 CWBL ~ReFr RBL VPWR sg13_lv_pmos w=0.15u l=0.13u ng=1 m=1 mm_ok=1
XM8 RBL RWL CWBL GND sg13_lv_nmos w=0.15u l=0.13u ng=1 m=1 mm_ok=1
XM9 ~ReFr RWL VPWR VPWR sg13_lv_pmos w=0.15u l=0.13u ng=1 m=1 mm_ok=1
XM10 ~ReFr RWL GND GND sg13_lv_nmos w=0.15u l=0.13u ng=1 m=1 mm_ok=1
XM11 RBL ~RBL VPWR VPWR sg13_lv_pmos w=0.15u l=0.13u ng=1 m=1 mm_ok=1
XM12 RBL ~RBL GND GND sg13_lv_nmos w=0.15u l=0.13u ng=1 m=1 mm_ok=1
*connector(8,1) ?1 VPWR ?1 VGND ?1 PreCh ?1 WWL ?1 WBL ?1 RWL ?1 RBL ?1 NodeC
**.ends
.GLOBAL GND
.end
