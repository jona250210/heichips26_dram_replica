* PEX produced on Wed Aug 26 17:18:36 CEST 2026 using scripts/sak-pex.sh with m=3 and s=1 (extresist threshold=0 mOhm, minres=0 mOhm, mindelay=0 ps)
* NGSPICE file created from dramcell_c_pex.ext - technology: ihp-sg13cmos5l

.subckt dramcell_c_pex VPWR PreCh RBL WWL WBL RWL VGND NodeC
X0 NodeC.t0 WWL.t0 a_470_550.t0 VGND.t2 sg13_lv_nmos ad=0.102p pd=1.28u as=0.102p ps=1.28u w=0.3u l=0.13u
X1 a_1504_535.t2 PreCh VPWR.t3 VPWR.t0 sg13_lv_pmos ad=0.1005p pd=1.34u as=0.1005p ps=1.34u w=0.15u l=0.13u
X2 a_470_550.t1 a_162_550# WBL.t1 VGND.t5 sg13_lv_nmos ad=0.1005p pd=1.34u as=0.1005p ps=1.34u w=0.15u l=0.13u
X3 a_470_550.t3 RWL.t1 WBL.t0 VPWR.t0 sg13_lv_pmos ad=0.1005p pd=1.34u as=0.1005p ps=1.34u w=0.15u l=0.13u
X4 a_1402_535.t0 NodeC.t1 VGND.t4 VGND.t3 sg13_lv_nmos ad=57f pd=0.68u as=0.102p ps=1.28u w=0.3u l=0.13u
X5 a_1504_535.t0 RWL.t0 a_1402_535.t0 VGND.t9 sg13_lv_nmos ad=57f pd=0.68u as=57f ps=0.68u w=0.3u l=0.13u
X6 a_1402_535.t1 RWL.t0 a_1504_535.t0 VGND.t10 sg13_lv_nmos ad=57f pd=0.68u as=57f ps=0.68u w=0.3u l=0.13u
X7 RBL.t2 a_1504_535.t3 VGND.t1 VGND.t0 sg13_lv_nmos ad=0.1005p pd=1.34u as=0.1005p ps=1.34u w=0.15u l=0.13u
X8 a_1504_535.t1 RWL.t0 a_1402_535.t1 VGND.t11 sg13_lv_nmos ad=0.102p pd=1.28u as=57f ps=0.68u w=0.3u l=0.13u
X9 a_162_550# RWL.t1 VGND.t7 VGND.t6 sg13_lv_nmos ad=0.1005p pd=1.34u as=0.1005p ps=1.34u w=0.15u l=0.13u
X10 a_470_550.t4 RWL.t1 RBL.t0 VGND.t8 sg13_lv_nmos ad=0.1005p pd=1.34u as=0.1005p ps=1.34u w=0.15u l=0.13u
X11 RBL.t1 a_1504_535.t3 VPWR.t1 VPWR.t0 sg13_lv_pmos ad=0.1005p pd=1.34u as=0.1005p ps=1.34u w=0.15u l=0.13u
X12 a_470_550.t2 a_162_550# RBL.t3 VPWR.t0 sg13_lv_pmos ad=0.1005p pd=1.34u as=0.1005p ps=1.34u w=0.15u l=0.13u
X13 a_162_550# RWL.t1 VPWR.t2 VPWR.t0 sg13_lv_pmos ad=0.1005p pd=1.34u as=0.1005p ps=1.34u w=0.15u l=0.13u
R0 WWL WWL.t0 34.0991
R1 NodeC.n0 NodeC.t0 17.2377
R2 NodeC.n0 NodeC.t1 15.2892
R3 NodeC NodeC.n0 0.0451875
R4 RBL RBL.n1 20.2915
R5 RBL RBL.n0 18.0202
R6 RBL.n0 RBL.t2 17.9461
R7 RBL.n1 RBL.t0 17.8916
R8 RBL.n0 RBL.t1 17.4236
R9 RBL.n1 RBL.t3 17.3691
R10 WBL WBL.n0 18.4248
R11 WBL.n0 WBL.t0 18.3896
R12 WBL.n0 WBL.t1 17.0031
R13 RWL RWL.t1 36.1971
R14 RWL RWL.t0 33.0291
R15 VPWR.n4 VPWR.t2 17.4963
R16 VPWR.n2 VPWR.t1 17.3762
R17 VPWR.n1 VPWR.t3 17.3167
R18 VPWR.n3 VPWR.n0 0.783164
R19 VPWR.n3 VPWR.n2 0.683922
R20 VPWR.n4 VPWR.n3 0.298426
R21 VPWR VPWR.n5 0.235251
R22 VPWR.n5 VPWR.n4 0.183547
R23 VPWR.n3 VPWR.t0 0.183296
R24 VPWR.n5 VPWR.n0 0.100573
R25 VPWR.n2 VPWR.n1 0.0968154
R26 VPWR.n1 VPWR.n0 0.0877484
R27 VGND.t5 VGND.t6 1044.07
R28 VGND.t8 VGND.t5 1044.07
R29 VGND.n56 VGND.t8 538.984
R30 VGND.n64 VGND.t0 538.984
R31 VGND.n35 VGND.t3 193.22
R32 VGND.t10 VGND.n21 193.22
R33 VGND.t2 VGND.n27 159.322
R34 VGND.t9 VGND.n21 152.542
R35 VGND.n49 VGND.t11 152.542
R36 VGND.n37 VGND.t9 77.9666
R37 VGND.t11 VGND.n19 77.9666
R38 VGND.n46 VGND.t2 71.1869
R39 VGND.t3 VGND.n23 37.2886
R40 VGND.n39 VGND.t10 37.2886
R41 VGND.n65 VGND.n44 29.6857
R42 VGND.n44 VGND.n41 29.6311
R43 VGND.n51 VGND.n28 29.6311
R44 VGND.n52 VGND.n28 29.6311
R45 VGND.n47 VGND.n25 29.6311
R46 VGND.n9 VGND.t7 18.0934
R47 VGND.n16 VGND.t1 17.9627
R48 VGND.n33 VGND.t4 17.7086
R49 VGND.n67 VGND.n66 17.0005
R50 VGND.n66 VGND.n18 17.0005
R51 VGND.n66 VGND.n40 17.0005
R52 VGND.n66 VGND.n19 17.0005
R53 VGND.n66 VGND.n20 17.0005
R54 VGND.n66 VGND.n39 17.0005
R55 VGND.n66 VGND.n38 17.0005
R56 VGND.n66 VGND.n21 17.0005
R57 VGND.n66 VGND.n22 17.0005
R58 VGND.n66 VGND.n37 17.0005
R59 VGND.n66 VGND.n36 17.0005
R60 VGND.n66 VGND.n23 17.0005
R61 VGND.n66 VGND.n24 17.0005
R62 VGND.n66 VGND.n35 17.0005
R63 VGND.n66 VGND.n34 17.0005
R64 VGND.n66 VGND.n26 17.0005
R65 VGND.n66 VGND.n32 17.0005
R66 VGND.n66 VGND.n27 17.0005
R67 VGND.n66 VGND.n0 17.0005
R68 VGND.n66 VGND.n1 17.0005
R69 VGND.n66 VGND.n29 17.0005
R70 VGND.n66 VGND.n30 17.0005
R71 VGND.n62 VGND.n46 17.0005
R72 VGND.n62 VGND.n21 17.0005
R73 VGND.n62 VGND.n49 17.0005
R74 VGND.n65 VGND.n64 14.8704
R75 VGND.n46 VGND.n25 14.8158
R76 VGND.n56 VGND.n52 14.8158
R77 VGND.n48 VGND.n23 14.8158
R78 VGND.n50 VGND.n39 14.8158
R79 VGND.n51 VGND.n27 14.8158
R80 VGND.n47 VGND.n35 14.8158
R81 VGND.n48 VGND.n37 14.8158
R82 VGND.n50 VGND.n19 14.8158
R83 VGND.n49 VGND.n41 14.8158
R84 VGND.n56 VGND.n53 8.501
R85 VGND.n57 VGND.n56 8.501
R86 VGND.n56 VGND.n31 8.501
R87 VGND.n64 VGND.n42 8.501
R88 VGND.n66 VGND.n43 8.48179
R89 VGND.n59 VGND.n58 8.46813
R90 VGND.n55 VGND.n54 8.46813
R91 VGND.n60 VGND.n45 8.46813
R92 VGND.n69 VGND.n68 5.66717
R93 VGND.n69 VGND.n2 5.66717
R94 VGND.n69 VGND.n15 5.66717
R95 VGND.n69 VGND.n3 5.66717
R96 VGND.n69 VGND.n14 5.66717
R97 VGND.n69 VGND.n4 5.66717
R98 VGND.n69 VGND.n13 5.66717
R99 VGND.n69 VGND.n5 5.66717
R100 VGND.n69 VGND.n12 5.66717
R101 VGND.n69 VGND.n6 5.66717
R102 VGND.n69 VGND.n11 5.66717
R103 VGND.n69 VGND.n7 5.66717
R104 VGND.n70 VGND.n69 5.66717
R105 VGND.n69 VGND.n8 5.66717
R106 VGND.n69 VGND.n10 5.66717
R107 VGND.n69 VGND.n16 5.66466
R108 VGND.n64 VGND.n63 4.251
R109 VGND.n61 VGND.n60 1.15617
R110 VGND.n66 VGND.n41 1.09359
R111 VGND.n66 VGND.n25 1.09359
R112 VGND.n66 VGND.n28 1.09359
R113 VGND.n62 VGND.n52 1.09359
R114 VGND.n62 VGND.n51 1.09359
R115 VGND.n62 VGND.n47 1.09359
R116 VGND.n62 VGND.n48 1.09359
R117 VGND.n62 VGND.n50 1.09359
R118 VGND.n62 VGND.n44 1.09359
R119 VGND.n61 VGND.n59 1.07882
R120 VGND.n66 VGND.n65 1.06629
R121 VGND.n62 VGND.n61 0.598174
R122 VGND.n69 VGND.n9 0.529257
R123 VGND.n59 VGND.n54 0.26499
R124 VGND VGND.n71 0.260603
R125 VGND.n60 VGND.n43 0.237658
R126 VGND.n54 VGND.n30 0.220745
R127 VGND.n30 VGND.n9 0.121842
R128 VGND.n43 VGND.n17 0.039413
R129 VGND.n17 VGND.n16 0.019753
R130 VGND.n68 VGND.n17 0.011837
R131 VGND.n29 VGND.n10 0.0112242
R132 VGND.n8 VGND.n1 0.0112242
R133 VGND.n32 VGND.n7 0.0112242
R134 VGND.n26 VGND.n11 0.0112242
R135 VGND.n34 VGND.n6 0.0112242
R136 VGND.n24 VGND.n12 0.0112242
R137 VGND.n36 VGND.n5 0.0112242
R138 VGND.n22 VGND.n13 0.0112242
R139 VGND.n38 VGND.n4 0.0112242
R140 VGND.n20 VGND.n14 0.0112242
R141 VGND.n40 VGND.n3 0.0112242
R142 VGND.n18 VGND.n15 0.0112242
R143 VGND.n67 VGND.n2 0.0112242
R144 VGND.n71 VGND.n70 0.0109178
R145 VGND.n30 VGND.n10 0.0106114
R146 VGND.n29 VGND.n8 0.0106114
R147 VGND.n70 VGND.n1 0.0106114
R148 VGND.n7 VGND.n0 0.0106114
R149 VGND.n32 VGND.n11 0.0106114
R150 VGND.n26 VGND.n6 0.0106114
R151 VGND.n24 VGND.n5 0.0106114
R152 VGND.n36 VGND.n13 0.0106114
R153 VGND.n22 VGND.n4 0.0106114
R154 VGND.n38 VGND.n14 0.0106114
R155 VGND.n20 VGND.n3 0.0106114
R156 VGND.n40 VGND.n15 0.0106114
R157 VGND.n18 VGND.n2 0.0106114
R158 VGND.n68 VGND.n67 0.0106114
R159 VGND.n33 VGND.n12 0.00877298
R160 VGND.n34 VGND.n33 0.00233844
R161 VGND.n63 VGND.n45 0.00175
R162 VGND.n63 VGND.n62 0.00124998
R163 VGND.n66 VGND.n31 0.001
R164 VGND.n58 VGND.n53 0.001
R165 VGND.n57 VGND.n55 0.001
R166 VGND.n66 VGND.n42 0.001
R167 VGND.n45 VGND.n42 0.001
R168 VGND.n55 VGND.n31 0.001
R169 VGND.n58 VGND.n57 0.001
R170 VGND.n62 VGND.n53 0.001
R171 VGND.n71 VGND.n0 0.000806407
R172 a_1402_535.t1 a_1402_535.t0 52.4493
R173 a_1504_535.n0 a_1504_535.t2 26.6517
R174 a_1504_535.n0 a_1504_535.t3 24.4449
R175 a_1504_535.n1 a_1504_535.t0 18.1326
R176 a_1504_535.t1 a_1504_535.n1 17.0005
R177 a_1504_535.n1 a_1504_535.n0 9.43644
R178 a_470_550.t0 a_470_550.n2 26.4602
R179 a_470_550.n0 a_470_550.t3 18.393
R180 a_470_550.n1 a_470_550.t2 18.393
R181 a_470_550.n0 a_470_550.t1 17.0005
R182 a_470_550.n1 a_470_550.t4 17.0005
R183 a_470_550.n2 a_470_550.n0 9.46781
R184 a_470_550.n2 a_470_550.n1 9.0005
C0 PreCh RBL 0.09865f
C1 WBL WWL 0.03015f
C2 WWL NodeC 0.02109f
C3 RWL WWL 0.03693f
C4 VPWR RBL 0.70965f
C5 RWL PreCh 0.0434f
C6 VPWR a_162_550# 0.21329f
C7 VPWR WBL 0.04946f
C8 a_162_550# RBL 0.38036f
C9 VPWR RWL 0.31054f
C10 a_162_550# WBL 0.14075f
C11 RWL RBL 0.60483f
C12 a_162_550# RWL 0.4505f
C13 WBL RWL 0.11396f
C14 RWL NodeC 0.05334f
C15 VPWR WWL 0.01008f
C16 VPWR PreCh 0.36098f
C17 WWL VGND 0.94396f
C18 NodeC VGND 0.30202f
C19 RBL VGND 1.80723f
C20 WBL VGND 0.44067f
C21 RWL VGND 2.14076f
C22 VPWR VGND 2.64335f
C23 a_470_550.t3 VGND 0.41828f
C24 a_470_550.t1 VGND 0.31998f
C25 a_470_550.n0 VGND 0.3015f
C26 a_470_550.t2 VGND 0.08917f
C27 a_470_550.t4 VGND 0.07836f
C28 a_470_550.n1 VGND 0.29179f
C29 a_470_550.n2 VGND 0.778f
C30 a_470_550.t0 VGND 0.23508f
C31 a_1504_535.t2 VGND 0.11716f
C32 a_1504_535.n0 VGND 0.44644f
C33 a_1504_535.t0 VGND 0.20476f
C34 a_1504_535.n1 VGND 0.15247f
C35 a_1504_535.t1 VGND 0.04369f
C36 a_1402_535.t0 VGND 0.38512f
C37 a_1402_535.t1 VGND 0.2032f
C38 VGND.t1 VGND 0.10469f
C39 VGND.t4 VGND 0.0305f
C40 VPWR.n0 VGND 0.03292f
C41 VPWR.t3 VGND 0.06059f
C42 VPWR.n1 VGND 0.06204f
C43 VPWR.n2 VGND 0.08679f
C44 VPWR.t0 VGND 0.67566f
C45 VPWR.n3 VGND 0.27291f
C46 VPWR.n4 VGND 0.14836f
C47 VPWR.n5 VGND 0.31196f
C48 WBL.t0 VGND 0.40301f
C49 WBL.t1 VGND 0.3066f
C50 WBL.n0 VGND 0.32045f
C51 RBL.t1 VGND 0.06071f
C52 RBL.t2 VGND 0.16849f
C53 RBL.n0 VGND 0.26687f
C54 RBL.t3 VGND 0.06103f
C55 RBL.t0 VGND 0.0647f
C56 RBL.n1 VGND 0.42274f
C57 NodeC.t0 VGND 0.14919f
C58 NodeC.n0 VGND 0.04781f
.ends
