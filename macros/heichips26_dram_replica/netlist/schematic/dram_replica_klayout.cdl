** sch_path: /home/bah67de/git/heichips26_dram_replica/macros/heichips26_dram_replica/schematic/xschem/dram_replica.sch
.subckt dram_replica VPWR VAPWR VGND rst_n clk ena uio_in[7] uio_in[6] uio_in[5] uio_in[4] uio_in[3] uio_in[2] uio_in[1] uio_in[0]
+ ui_in[7] ui_in[6] ui_in[5] ui_in[4] ui_in[3] ui_in[2] ui_in[1] ui_in[0] uio_oe[7] uio_oe[6] uio_oe[5] uio_oe[4] uio_oe[3] uio_oe[2]
+ uio_oe[1] uio_oe[0] uio_out[7] uio_out[6] uio_out[5] uio_out[4] uio_out[3] uio_out[2] uio_out[1] uio_out[0] uo_out[7] uo_out[6] uo_out[5]
+ uo_out[4] uo_out[3] uo_out[2] uo_out[1] uo_out[0]
*.PININFO rst_n:I clk:I ena:I uio_in[7]:I ui_in[7]:I uio_oe[7]:O uio_oe[6]:O uio_oe[5]:O uio_oe[4]:O uio_oe[3]:O uio_oe[2]:O
*+ uio_oe[1]:O uio_oe[0]:O uio_out[7]:O uio_out[6]:O uio_out[5]:O uio_out[4]:O uio_out[3]:O uio_out[2]:O uio_out[1]:O uio_out[0]:O uo_out[7]:O
*+ uo_out[6]:O uo_out[5]:O uo_out[4]:O uo_out[3]:O uo_out[2]:O uo_out[1]:O uo_out[0]:O VPWR:B VGND:B VAPWR:B ui_in[6]:I ui_in[5]:I ui_in[4]:I
*+ ui_in[3]:I ui_in[2]:I ui_in[1]:I ui_in[0]:I uio_in[6]:I uio_in[5]:I uio_in[4]:I uio_in[3]:I uio_in[2]:I uio_in[1]:I uio_in[0]:I
MM4 CWBL ui_in[1] net2 VGND sg13_lv_nmos w=0.3u l=0.13u ng=1
MM5 net1 net2 VGND VGND sg13_lv_nmos w=0.3u l=0.13u ng=1
MM6 nRBL ui_in[2] net1 VGND sg13_lv_nmos w=0.9u l=0.13u ng=3
MM2 nRBL ui_in[3] VPWR VPWR sg13_lv_pmos w=0.15u l=0.13u ng=1
MM1 CWBL ui_in[2] ui_in[0] VPWR sg13_lv_pmos w=0.15u l=0.13u ng=1
MM7 ui_in[0] nReFr CWBL VGND sg13_lv_nmos w=0.15u l=0.13u ng=1
MM3 CWBL nReFr uo_out[0] VPWR sg13_lv_pmos w=0.15u l=0.13u ng=1
MM8 uo_out[0] ui_in[2] CWBL VGND sg13_lv_nmos w=0.15u l=0.13u ng=1
MM9 nReFr ui_in[2] VPWR VPWR sg13_lv_pmos w=0.15u l=0.13u ng=1
MM10 nReFr ui_in[2] VGND VGND sg13_lv_nmos w=0.15u l=0.13u ng=1
MM11 uo_out[0] nRBL VPWR VPWR sg13_lv_pmos w=0.15u l=0.13u ng=1
MM12 uo_out[0] nRBL VGND VGND sg13_lv_nmos w=0.15u l=0.13u ng=1
*connector(3,1) ?1 rst_n ?1 clk ?1 ena
*connector(8,1) ?1 uio_in[7] ?1 uio_in[6] ?1 uio_in[5] ?1 uio_in[4] ?1 uio_in[3] ?1 uio_in[2] ?1 uio_in[1] ?1 uio_in[0]
*connector(8,1) ?1 ui_in[7] ?1 ui_in[6] ?1 ui_in[5] ?1 ui_in[4] ?1 ui_in[3] ?1 ui_in[2] ?1 ui_in[1] ?1 ui_in[0]
*connector(8,1) ?1 uio_oe[7] ?1 uio_oe[6] ?1 uio_oe[5] ?1 uio_oe[4] ?1 uio_oe[3] ?1 uio_oe[2] ?1 uio_oe[1] ?1 uio_oe[0]
*connector(8,1) ?1 uio_out[7] ?1 uio_out[6] ?1 uio_out[5] ?1 uio_out[4] ?1 uio_out[3] ?1 uio_out[2] ?1 uio_out[1] ?1 uio_out[0]
*connector(8,1) ?1 uo_out[7] ?1 uo_out[6] ?1 uo_out[5] ?1 uo_out[4] ?1 uo_out[3] ?1 uo_out[2] ?1 uo_out[1] ?1 uo_out[0]
*connector(3,1) ?1 VPWR ?1 VAPWR ?1 VGND
MM13 VGND VPWR VGND VGND sg13_lv_pmos w=10.0u l=10.0u ng=1
MM14 VGND VAPWR VGND VGND sg13_lv_pmos w=10.0u l=10.0u ng=1
.ends
