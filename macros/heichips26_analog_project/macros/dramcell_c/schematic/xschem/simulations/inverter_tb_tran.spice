** sch_path: /home/bah67de/git/heichips26_dram_replica/macros/heichips26_analog_project/macros/dramcell_2_0/testbenches/xschem/inverter_tb_tran.sch
**.subckt inverter_tb_tran
vpulse WWL GND pulse(0 {VPWR} 50050n 1n 1n 10n 100u)
VPWR VPWR GND {VPWR}
vpulse1 WBL GND pulse(0 {VPWR} 50u 1n 1n 100n 400u)
vpulse3 RWL GND pulse(0 {VPWR} 150040n 1n 1n 30n 200u)
x3 WWL CWBL RWL ~RBL GND NodeC dramcell_2_0
XM1 RBL ~RBL VPWR VPWR sg13_lv_pmos w=0.15u l=0.13u ng=1 m=1 mm_ok=1
XM4 RBL ~RBL GND GND sg13_lv_nmos w=0.15u l=0.13u ng=1 m=1 mm_ok=1
XM6 CWBL RWL WBL VPWR sg13_lv_pmos w=0.15u l=0.13u ng=1 m=1 mm_ok=1
XM7 WBL ~ReFr CWBL GND sg13_lv_nmos w=0.15u l=0.13u ng=1 m=1 mm_ok=1
XM8 ~ReFr RWL VPWR VPWR sg13_lv_pmos w=0.15u l=0.13u ng=1 m=1 mm_ok=1
XM9 ~ReFr RWL GND GND sg13_lv_nmos w=0.15u l=0.13u ng=1 m=1 mm_ok=1
XM3 CWBL ~ReFr RBL VPWR sg13_lv_pmos w=0.15u l=0.13u ng=1 m=1 mm_ok=1
XM5 RBL RWL CWBL GND sg13_lv_nmos w=0.15u l=0.13u ng=1 m=1 mm_ok=1
XM2 ~RBL PreCh VPWR VPWR sg13_lv_pmos w=0.15u l=0.13u ng=1 m=1 mm_ok=1
vpulse2 PreCh GND pulse({VPWR} 0 150008n 1n 1n 10n 200u)
**** begin user architecture code

*.include ../../../netlist/pex/heichips26_analog_project_magic_pex_3.spice
*.include heichips26_analog_project.save
.param VPWR=1.5
.csparam VPWR=VPWR
.param VAPWR=1.5
.csparam VAPWR=VAPWR
.param Vcm=VAPWR/2
.param temp=27
.param Cload=10p
.param Rload=1k
.param w=25u
.param l=0.13u
.options savecurrents klu method=gear reltol=1e-3 abstol=1e-12 gmin=1e-12
.control
save all

* Operating Point Analysis
op
remzerovec
write inverter_tb_tran.raw
set appendwrite

* Transient Analysis
tran 10n 800u
write inverter_tb_tran.raw

unset appendwrite
set wr_vecnames
set wr_singlescale
*wrdata ../plot_simulations/data/inverter_tb_tran.txt

*quit
.endc

.lib cornerMOSlv.lib mos_tt
.lib cornerMOShv.lib mos_tt
.lib cornerRES.lib res_typ
.lib cornerDIO.lib dio_tt
.lib cornerCAP.lib cap_typ

**** end user architecture code
**.ends

* expanding   symbol:  dramcell_2_0.sym # of pins=6
** sym_path: /home/bah67de/git/heichips26_dram_replica/macros/heichips26_analog_project/macros/dramcell_2_0/schematic/xschem/dramcell_2_0.sym
** sch_path: /home/bah67de/git/heichips26_dram_replica/macros/heichips26_analog_project/macros/dramcell_2_0/schematic/xschem/dramcell_2_0.sch
.subckt dramcell_2_0 WWL WBL RWL RBL VGND NodeC
*.opin RBL
*.ipin WWL
*.ipin WBL
*.ipin RWL
*.iopin VGND
*.iopin NodeC
XM4 WBL WWL NodeC VGND sg13_lv_nmos w=0.3u l=0.13u ng=1 m=1 mm_ok=1
XM5 net1 NodeC VGND VGND sg13_lv_nmos w=0.3u l=0.13u ng=1 m=1 mm_ok=1
XM6 RBL RWL net1 VGND sg13_lv_nmos w=0.9u l=0.13u ng=3 m=1 mm_ok=1
*connector(6,1) ?1 VGND ?1 WWL ?1 WBL ?1 RWL ?1 RBL ?1 NodeC
.ends

.GLOBAL GND
.end
