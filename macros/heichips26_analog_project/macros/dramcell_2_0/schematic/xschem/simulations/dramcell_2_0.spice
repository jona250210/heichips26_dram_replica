** sch_path: /home/bah67de/git/heichips26_dram_replica/macros/heichips26_analog_project/macros/dramcell_2_0/schematic/xschem/dramcell_2_0.sch
**.subckt dramcell_2_0 WWL WBL RWL RBL VGND VPWR NodeC
*.opin RBL
*.ipin WWL
*.ipin WBL
*.ipin RWL
*.iopin VPWR
*.iopin VGND
*.iopin NodeC
*connector(8,1) ?1 net1 ?1 VPWR ?1 VGND ?1 WWL ?1 WBL ?1 RWL ?1 RBL ?1 NodeC
* noconn #net1
XM4 WBL WWL NodeC VGND sg13_lv_nmos w=0.5u l=0.18u ng=1 m=1 mm_ok=1
XC3 NodeC VGND cap_cmomi w=3e-6 l=3e-6 mmin=1 mmax=4 feed=double subblock=0 m=1 mm_ok=1
XM5 net2 NodeC VGND VGND sg13_lv_nmos w=10u l=0.13u ng=1 m=1 mm_ok=1
XM6 RBL RWL net2 VGND sg13_lv_nmos w=1u l=0.13u ng=1 m=1 mm_ok=1
**.ends
.end
