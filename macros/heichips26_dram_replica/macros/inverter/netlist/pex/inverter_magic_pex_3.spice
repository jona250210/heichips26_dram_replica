* PEX produced on Mon Sep 14 22:51:23 CEST 2026 using scripts/sak-pex.sh with m=3 and s=1 (extresist threshold=10000 mOhm, minres=1000 mOhm, mindelay=1 ps)
* NGSPICE file created from inverter_pex.ext - technology: ihp-sg13cmos5l

.subckt inverter_pex VDD vin vout VSS
X0 vout vin VDD VDD sg13_lv_pmos ad=1.14p pd=6.38u as=1.14p ps=6.38u w=6u l=1u
X1 VDD vin vout VDD sg13_lv_pmos ad=1.14p pd=6.38u as=1.14p ps=6.38u w=6u l=1u
X2 vout vin VDD VDD sg13_lv_pmos ad=1.14p pd=6.38u as=1.14p ps=6.38u w=6u l=1u
X3 vout vin VSS VSS.t11 sg13_lv_nmos ad=0.19p pd=1.38u as=0.19p ps=1.38u w=1u l=1u
X4 vout vin VSS.t1 VSS.t0 sg13_lv_nmos ad=0.19p pd=1.38u as=0.19p ps=1.38u w=1u l=1u
X5 VSS.t24 VSS VSS.t1 VSS.t22 sg13_lv_nmos ad=0.34p pd=2.68u as=0 ps=0 w=1u l=1u
X6 VSS vin vout VSS.t16 sg13_lv_nmos ad=0.19p pd=1.38u as=0.19p ps=1.38u w=1u l=1u
X7 vout vin VDD VDD sg13_lv_pmos ad=1.14p pd=6.38u as=1.14p ps=6.38u w=6u l=1u
X8 VDD vin vout VDD sg13_lv_pmos ad=1.14p pd=6.38u as=1.14p ps=6.38u w=6u l=1u
X9 vout vin VSS VSS.t15 sg13_lv_nmos ad=0.19p pd=1.38u as=0.19p ps=1.38u w=1u l=1u
X10 vout vin VDD VDD sg13_lv_pmos ad=1.14p pd=6.38u as=1.14p ps=6.38u w=6u l=1u
X11 VSS vin vout VSS.t6 sg13_lv_nmos ad=0.19p pd=1.38u as=0.19p ps=1.38u w=1u l=1u
X12 VSS.t21 vin vout VSS.t20 sg13_lv_nmos ad=0.19p pd=1.38u as=0.19p ps=1.38u w=1u l=1u
X13 VDD vin vout VDD sg13_lv_pmos ad=1.14p pd=6.38u as=1.14p ps=6.38u w=6u l=1u
X14 vout vin VDD VDD sg13_lv_pmos ad=1.14p pd=6.38u as=1.14p ps=6.38u w=6u l=1u
X15 VDD vin vout VDD sg13_lv_pmos ad=1.14p pd=6.38u as=1.14p ps=6.38u w=6u l=1u
X16 vout vin VDD VDD sg13_lv_pmos ad=1.14p pd=6.38u as=1.14p ps=6.38u w=6u l=1u
X17 vout vin VSS VSS.t19 sg13_lv_nmos ad=0.19p pd=1.38u as=0.19p ps=1.38u w=1u l=1u
X18 VSS vin vout VSS.t10 sg13_lv_nmos ad=0.19p pd=1.38u as=0.19p ps=1.38u w=1u l=1u
X19 VDD vin vout VDD sg13_lv_pmos ad=1.14p pd=6.38u as=1.14p ps=6.38u w=6u l=1u
X20 vout vin VDD VDD sg13_lv_pmos ad=1.14p pd=6.38u as=1.14p ps=6.38u w=6u l=1u
X21 VDD VDD VDD VDD sg13_lv_pmos ad=2.04p pd=12.68u as=0.14199n ps=0.28418m w=6u l=1u
X22 vout vin VSS VSS.t5 sg13_lv_nmos ad=0.19p pd=1.38u as=0.19p ps=1.38u w=1u l=1u
X23 VSS vin vout VSS.t14 sg13_lv_nmos ad=0.19p pd=1.38u as=0.19p ps=1.38u w=1u l=1u
X24 VDD vin vout VDD sg13_lv_pmos ad=1.14p pd=6.38u as=1.14p ps=6.38u w=6u l=1u
X25 VDD vin vout VDD sg13_lv_pmos ad=1.14p pd=6.38u as=1.14p ps=6.38u w=6u l=1u
X26 VSS vin vout VSS.t4 sg13_lv_nmos ad=0.19p pd=1.38u as=0.19p ps=1.38u w=1u l=1u
X27 vout vin VDD VDD sg13_lv_pmos ad=1.14p pd=6.38u as=1.14p ps=6.38u w=6u l=1u
X28 VSS vin vout VSS.t2 sg13_lv_nmos ad=0.19p pd=1.38u as=0.19p ps=1.38u w=1u l=1u
X29 vout vin VSS VSS.t9 sg13_lv_nmos ad=0.19p pd=1.38u as=0.19p ps=1.38u w=1u l=1u
X30 VSS vin vout VSS.t18 sg13_lv_nmos ad=0.19p pd=1.38u as=0.19p ps=1.38u w=1u l=1u
X31 vout vin VSS VSS.t3 sg13_lv_nmos ad=0.19p pd=1.38u as=0.19p ps=1.38u w=1u l=1u
X32 VDD vin vout VDD sg13_lv_pmos ad=1.14p pd=6.38u as=1.14p ps=6.38u w=6u l=1u
X33 vout vin VSS VSS.t17 sg13_lv_nmos ad=0.19p pd=1.38u as=0.19p ps=1.38u w=1u l=1u
X34 vout vin VDD VDD sg13_lv_pmos ad=1.14p pd=6.38u as=1.14p ps=6.38u w=6u l=1u
X35 VSS vin vout VSS.t8 sg13_lv_nmos ad=0.19p pd=1.38u as=0.19p ps=1.38u w=1u l=1u
X36 VDD vin vout VDD sg13_lv_pmos ad=1.14p pd=6.38u as=1.14p ps=6.38u w=6u l=1u
X37 VDD VDD VDD VDD sg13_lv_pmos ad=1.14p pd=6.38u as=0 ps=0 w=6u l=1u
X38 VDD vin vout VDD sg13_lv_pmos ad=1.14p pd=6.38u as=1.14p ps=6.38u w=6u l=1u
X39 vout vin VSS VSS.t7 sg13_lv_nmos ad=0.19p pd=1.38u as=0.19p ps=1.38u w=1u l=1u
X40 vout vin VSS VSS.t13 sg13_lv_nmos ad=0.19p pd=1.38u as=0.19p ps=1.38u w=1u l=1u
X41 vout vin VDD VDD sg13_lv_pmos ad=1.14p pd=6.38u as=1.14p ps=6.38u w=6u l=1u
X42 VSS vin vout VSS.t12 sg13_lv_nmos ad=0.19p pd=1.38u as=0.19p ps=1.38u w=1u l=1u
X43 VSS.t21 VSS VSS.t26 VSS.t25 sg13_lv_nmos ad=0.19p pd=1.38u as=0 ps=0 w=1u l=1u
R0 VSS.t0 VSS.n39 177.45
R1 VSS.t20 VSS.n99 177.45
R2 VSS.t2 VSS.n38 166.359
R3 VSS.n95 VSS.t19 166.359
R4 VSS.t3 VSS.n37 155.268
R5 VSS.n93 VSS.t18 155.268
R6 VSS.t4 VSS.n34 144.178
R7 VSS.n91 VSS.t17 144.178
R8 VSS.t5 VSS.n33 133.088
R9 VSS.n89 VSS.t16 133.088
R10 VSS.t6 VSS.n30 121.996
R11 VSS.n87 VSS.t15 121.996
R12 VSS.t7 VSS.n29 110.906
R13 VSS.n73 VSS.t10 110.906
R14 VSS.t11 VSS.n21 110.906
R15 VSS.n85 VSS.t14 110.906
R16 VSS.t8 VSS.n28 99.8157
R17 VSS.n71 VSS.t9 99.8157
R18 VSS.t12 VSS.n20 99.8157
R19 VSS.n83 VSS.t13 99.8157
R20 VSS.n67 VSS.t8 88.7251
R21 VSS.t9 VSS.n27 88.7251
R22 VSS.n79 VSS.t12 88.7251
R23 VSS.t13 VSS.n19 88.7251
R24 VSS.n63 VSS.t7 77.6345
R25 VSS.t10 VSS.n24 77.6345
R26 VSS.n75 VSS.t11 77.6345
R27 VSS.t14 VSS.n16 77.6345
R28 VSS.n59 VSS.t6 66.5439
R29 VSS.t15 VSS.n13 66.5439
R30 VSS.n57 VSS.t5 55.4534
R31 VSS.t16 VSS.n10 55.4534
R32 VSS.n53 VSS.t4 44.3628
R33 VSS.t17 VSS.n7 44.3628
R34 VSS.n51 VSS.t3 33.2722
R35 VSS.t18 VSS.n4 33.2722
R36 VSS.n23 VSS.n22 29.2386
R37 VSS.n74 VSS.n22 29.2386
R38 VSS.n3 VSS.n2 28.8069
R39 VSS.n6 VSS.n5 28.8069
R40 VSS.n9 VSS.n8 28.8069
R41 VSS.n12 VSS.n11 28.8069
R42 VSS.n15 VSS.n14 28.8069
R43 VSS.n18 VSS.n17 28.8069
R44 VSS.n26 VSS.n25 28.8069
R45 VSS.n32 VSS.n31 28.8069
R46 VSS.n36 VSS.n35 28.8069
R47 VSS.n102 VSS.n101 28.8069
R48 VSS.n0 VSS.t22 7.18678
R49 VSS.n41 VSS.n40 28.8069
R50 VSS.n42 VSS.n41 28.8069
R51 VSS.n45 VSS.n44 28.8069
R52 VSS.n46 VSS.n45 28.8069
R53 VSS.n49 VSS.n48 28.8069
R54 VSS.n50 VSS.n49 28.8069
R55 VSS.n52 VSS.n35 28.8069
R56 VSS.n55 VSS.n54 28.8069
R57 VSS.n56 VSS.n55 28.8069
R58 VSS.n58 VSS.n31 28.8069
R59 VSS.n61 VSS.n60 28.8069
R60 VSS.n62 VSS.n61 28.8069
R61 VSS.n65 VSS.n64 28.8069
R62 VSS.n66 VSS.n65 28.8069
R63 VSS.n69 VSS.n68 28.8069
R64 VSS.n70 VSS.n69 28.8069
R65 VSS.n72 VSS.n25 28.8069
R66 VSS.n77 VSS.n76 28.8069
R67 VSS.n78 VSS.n77 28.8069
R68 VSS.n81 VSS.n80 28.8069
R69 VSS.n82 VSS.n81 28.8069
R70 VSS.n84 VSS.n17 28.8069
R71 VSS.n86 VSS.n14 28.8069
R72 VSS.n88 VSS.n11 28.8069
R73 VSS.n90 VSS.n8 28.8069
R74 VSS.n92 VSS.n5 28.8069
R75 VSS.n94 VSS.n2 28.8069
R76 VSS.n97 VSS.n96 28.8069
R77 VSS.n98 VSS.n97 28.8069
R78 VSS.n104 VSS.n102 28.8069
R79 VSS.n101 VSS.n100 28.8069
R80 VSS.n47 VSS.t2 22.1816
R81 VSS.t19 VSS.n1 22.1816
R82 VSS VSS.n99 17.0005
R83 VSS VSS.n1 17.0005
R84 VSS VSS.n95 17.0005
R85 VSS VSS.n4 17.0005
R86 VSS VSS.n93 17.0005
R87 VSS VSS.n7 17.0005
R88 VSS VSS.n91 17.0005
R89 VSS VSS.n10 17.0005
R90 VSS VSS.n89 17.0005
R91 VSS VSS.n13 17.0005
R92 VSS VSS.n87 17.0005
R93 VSS VSS.n16 17.0005
R94 VSS VSS.n85 17.0005
R95 VSS VSS.n19 17.0005
R96 VSS VSS.n83 17.0005
R97 VSS VSS.n20 17.0005
R98 VSS VSS.n79 17.0005
R99 VSS VSS.n21 17.0005
R100 VSS VSS.n75 17.0005
R101 VSS VSS.n24 17.0005
R102 VSS VSS.n73 17.0005
R103 VSS VSS.n27 17.0005
R104 VSS VSS.n71 17.0005
R105 VSS VSS.n28 17.0005
R106 VSS VSS.n67 17.0005
R107 VSS VSS.n29 17.0005
R108 VSS VSS.n63 17.0005
R109 VSS VSS.n30 17.0005
R110 VSS VSS.n59 17.0005
R111 VSS VSS.n33 17.0005
R112 VSS VSS.n57 17.0005
R113 VSS VSS.n34 17.0005
R114 VSS VSS.n53 17.0005
R115 VSS VSS.n37 17.0005
R116 VSS VSS.n51 17.0005
R117 VSS VSS.n38 17.0005
R118 VSS VSS.n47 17.0005
R119 VSS VSS.n39 17.0005
R120 VSS VSS.n43 17.0005
R121 VSS.t21 VSS 5.66439
R122 VSS VSS.t26 5.6636
R123 VSS.n103 VSS 17.0005
R124 VSS.t24 VSS 5.66833
R125 VSS.t1 VSS 5.66856
R126 VSS.n104 VSS.n103 14.4037
R127 VSS.t25 VSS 15.6529
R128 VSS.n43 VSS.n42 14.4037
R129 VSS.n47 VSS.n46 14.4037
R130 VSS.n51 VSS.n50 14.4037
R131 VSS.n53 VSS.n52 14.4037
R132 VSS.n57 VSS.n56 14.4037
R133 VSS.n59 VSS.n58 14.4037
R134 VSS.n63 VSS.n62 14.4037
R135 VSS.n67 VSS.n66 14.4037
R136 VSS.n71 VSS.n70 14.4037
R137 VSS.n73 VSS.n72 14.4037
R138 VSS.n75 VSS.n74 14.4037
R139 VSS.n79 VSS.n78 14.4037
R140 VSS.n83 VSS.n82 14.4037
R141 VSS.n85 VSS.n84 14.4037
R142 VSS.n87 VSS.n86 14.4037
R143 VSS.n89 VSS.n88 14.4037
R144 VSS.n91 VSS.n90 14.4037
R145 VSS.n93 VSS.n92 14.4037
R146 VSS.n95 VSS.n94 14.4037
R147 VSS.n99 VSS.n98 14.4037
R148 VSS.n100 VSS.t25 14.4037
R149 VSS.n40 VSS.n0 29.4038
R150 VSS.n44 VSS.n39 14.4037
R151 VSS.n48 VSS.n38 14.4037
R152 VSS.n37 VSS.n36 14.4037
R153 VSS.n54 VSS.n34 14.4037
R154 VSS.n33 VSS.n32 14.4037
R155 VSS.n60 VSS.n30 14.4037
R156 VSS.n64 VSS.n29 14.4037
R157 VSS.n68 VSS.n28 14.4037
R158 VSS.n27 VSS.n26 14.4037
R159 VSS.n24 VSS.n23 14.4037
R160 VSS.n76 VSS.n21 14.4037
R161 VSS.n80 VSS.n20 14.4037
R162 VSS.n19 VSS.n18 14.4037
R163 VSS.n16 VSS.n15 14.4037
R164 VSS.n13 VSS.n12 14.4037
R165 VSS.n10 VSS.n9 14.4037
R166 VSS.n7 VSS.n6 14.4037
R167 VSS.n4 VSS.n3 14.4037
R168 VSS.n96 VSS.n1 14.4037
R169 VSS.n43 VSS.t0 11.0911
R170 VSS.n103 VSS.t20 11.0911
R171 VSS.n0 VSS 1.32503
R172 VSS VSS.n104 1.29964
R173 VSS VSS.n97 1.29964
R174 VSS VSS.n2 1.29964
R175 VSS VSS.n5 1.29964
R176 VSS VSS.n8 1.29964
R177 VSS VSS.n11 1.29964
R178 VSS VSS.n14 1.29964
R179 VSS VSS.n17 1.29964
R180 VSS VSS.n81 1.29964
R181 VSS VSS.n77 1.29964
R182 VSS VSS.n25 1.29964
R183 VSS VSS.n69 1.29964
R184 VSS VSS.n65 1.29964
R185 VSS VSS.n61 1.29964
R186 VSS VSS.n31 1.29964
R187 VSS VSS.n55 1.29964
R188 VSS VSS.n35 1.29964
R189 VSS VSS.n49 1.29964
R190 VSS VSS.n45 1.29964
R191 VSS VSS.n101 1.29964
R192 VSS.n40 VSS 1.29964
R193 VSS.n42 VSS 1.29964
R194 VSS.n44 VSS 1.29964
R195 VSS.n46 VSS 1.29964
R196 VSS.n48 VSS 1.29964
R197 VSS.n50 VSS 1.29964
R198 VSS.n36 VSS 1.29964
R199 VSS.n52 VSS 1.29964
R200 VSS.n54 VSS 1.29964
R201 VSS.n56 VSS 1.29964
R202 VSS.n32 VSS 1.29964
R203 VSS.n58 VSS 1.29964
R204 VSS.n60 VSS 1.29964
R205 VSS.n62 VSS 1.29964
R206 VSS.n64 VSS 1.29964
R207 VSS.n66 VSS 1.29964
R208 VSS.n68 VSS 1.29964
R209 VSS.n70 VSS 1.29964
R210 VSS.n26 VSS 1.29964
R211 VSS.n72 VSS 1.29964
R212 VSS.n23 VSS 1.29964
R213 VSS.n74 VSS 1.29964
R214 VSS.n76 VSS 1.29964
R215 VSS.n78 VSS 1.29964
R216 VSS.n80 VSS 1.29964
R217 VSS.n82 VSS 1.29964
R218 VSS.n18 VSS 1.29964
R219 VSS.n84 VSS 1.29964
R220 VSS.n15 VSS 1.29964
R221 VSS.n86 VSS 1.29964
R222 VSS.n12 VSS 1.29964
R223 VSS.n88 VSS 1.29964
R224 VSS.n9 VSS 1.29964
R225 VSS.n90 VSS 1.29964
R226 VSS.n6 VSS 1.29964
R227 VSS.n92 VSS 1.29964
R228 VSS.n3 VSS 1.29964
R229 VSS.n94 VSS 1.29964
R230 VSS.n96 VSS 1.29964
R231 VSS.n98 VSS 1.29964
R232 VSS.n102 VSS 1.29964
R233 VSS.n100 VSS 1.29964
R234 VSS VSS.n41 1.29964
R235 VSS VSS.n22 1.08379
C0 vin vout 18.6541f
C1 vin VDD 29.702f
C2 VDD vout 19.3894f
C3 vout VSS 13.72425f
.ends
