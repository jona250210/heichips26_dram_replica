* PEX produced on Wed Aug 19 18:08:50 CEST 2026 using scripts/sak-pex.sh with m=3 and s=1 (extresist threshold=10000 mOhm, minres=1000 mOhm, mindelay=1 ps)
* NGSPICE file created from heichips26_analog_project_pex.ext - technology: ihp-sg13cmos5l

.subckt heichips26_analog_project_pex VPWR VAPWR VGND rst_n clk ena uio_in[7]
+ uio_in[6] uio_in[5] uio_in[4] uio_in[3] uio_in[2] uio_in[1] uio_in[0] ui_in[7]
+ ui_in[6] ui_in[5] ui_in[4] ui_in[3] ui_in[2] ui_in[1] ui_in[0] uio_oe[7]
+ uio_oe[6] uio_oe[5] uio_oe[4] uio_oe[3] uio_oe[2] uio_oe[1] uio_oe[0]
+ uio_out[7] uio_out[6] uio_out[5] uio_out[4] uio_out[3] uio_out[2] uio_out[1]
+ uio_out[0] uo_out[7] uo_out[6] uo_out[5] uo_out[4] uo_out[3] uo_out[2]
+ uo_out[1] uo_out[0] analog_2 analog_1 analog_0
X0 VAPWR VAPWR VAPWR VAPWR sg13_lv_pmos ad=1.14p pd=6.38u as=0.28875n ps=0.61464m w=6u l=1u
X1 VGND.t37 VGND.t34 VGND.t36 VGND.t35 sg13_lv_nmos ad=0.34p pd=2.68u as=0 ps=0 w=1u l=1u
X2 analog_1 analog_0 VGND.t4 VGND.t3 sg13_lv_nmos ad=0.19p pd=1.38u as=0.19p ps=1.38u w=1u l=1u
X3 analog_1 analog_0 VAPWR VAPWR sg13_lv_pmos ad=1.14p pd=6.38u as=1.14p ps=6.38u w=6u l=1u
X4 VAPWR ui_in[0].t1 analog_2 VAPWR sg13_lv_pmos ad=1.14p pd=6.38u as=1.14p ps=6.38u w=6u l=1u
X5 VAPWR analog_0 analog_1 VAPWR sg13_lv_pmos ad=1.14p pd=6.38u as=1.14p ps=6.38u w=6u l=1u
X6 analog_1 analog_0 VGND.t6 VGND.t7 sg13_lv_nmos ad=0.19p pd=1.38u as=0.19p ps=1.38u w=1u l=1u
X7 VAPWR analog_0 analog_1 VAPWR sg13_lv_pmos ad=1.14p pd=6.38u as=1.14p ps=6.38u w=6u l=1u
X8 VAPWR analog_0 analog_1 VAPWR sg13_lv_pmos ad=1.14p pd=6.38u as=1.14p ps=6.38u w=6u l=1u
X9 VGND.t12 analog_0 analog_1 VGND.t11 sg13_lv_nmos ad=0.19p pd=1.38u as=0.19p ps=1.38u w=1u l=1u
X10 VAPWR analog_0 analog_1 VAPWR sg13_lv_pmos ad=1.14p pd=6.38u as=1.14p ps=6.38u w=6u l=1u
X11 analog_1 analog_0 VAPWR VAPWR sg13_lv_pmos ad=1.14p pd=6.38u as=1.14p ps=6.38u w=6u l=1u
X12 analog_2 ui_in[0].t1 VAPWR VAPWR sg13_lv_pmos ad=1.14p pd=6.38u as=1.14p ps=6.38u w=6u l=1u
X13 VGND.t9 analog_0 analog_1 VGND.t8 sg13_lv_nmos ad=0.19p pd=1.38u as=0.19p ps=1.38u w=1u l=1u
X14 VGND.t15 analog_0 analog_1 VGND.t14 sg13_lv_nmos ad=0.19p pd=1.38u as=0.19p ps=1.38u w=1u l=1u
X15 analog_1 analog_0 VAPWR VAPWR sg13_lv_pmos ad=1.14p pd=6.38u as=1.14p ps=6.38u w=6u l=1u
X16 analog_2 ui_in[0].t1 VAPWR VAPWR sg13_lv_pmos ad=1.14p pd=6.38u as=1.14p ps=6.38u w=6u l=1u
X17 VAPWR analog_0 analog_1 VAPWR sg13_lv_pmos ad=1.14p pd=6.38u as=1.14p ps=6.38u w=6u l=1u
X18 VAPWR ui_in[0].t1 analog_2 VAPWR sg13_lv_pmos ad=1.14p pd=6.38u as=1.14p ps=6.38u w=6u l=1u
X19 VGND.t18 analog_0 analog_1 VGND.t17 sg13_lv_nmos ad=0.19p pd=1.38u as=0.19p ps=1.38u w=1u l=1u
X20 analog_1 analog_0 VGND.t24 VGND.t25 sg13_lv_nmos ad=0.19p pd=1.38u as=0.19p ps=1.38u w=1u l=1u
X21 analog_2 ui_in[0].t1 VAPWR VAPWR sg13_lv_pmos ad=1.14p pd=6.38u as=1.14p ps=6.38u w=6u l=1u
X22 VGND.t41 ui_in[0].t0 analog_2 VGND.t32 sg13_lv_nmos ad=0.19p pd=1.38u as=0.19p ps=1.38u w=1u l=1u
X23 analog_1 analog_0 VGND.t21 VGND.t22 sg13_lv_nmos ad=0.19p pd=1.38u as=0.19p ps=1.38u w=1u l=1u
X24 VAPWR analog_0 analog_1 VAPWR sg13_lv_pmos ad=1.14p pd=6.38u as=1.14p ps=6.38u w=6u l=1u
X25 VAPWR ui_in[0].t1 analog_2 VAPWR sg13_lv_pmos ad=1.14p pd=6.38u as=1.14p ps=6.38u w=6u l=1u
X26 analog_2 ui_in[0].t1 VAPWR VAPWR sg13_lv_pmos ad=1.14p pd=6.38u as=1.14p ps=6.38u w=6u l=1u
X27 analog_2 ui_in[0].t0 VGND.t36 VGND.t3 sg13_lv_nmos ad=0.19p pd=1.38u as=0.19p ps=1.38u w=1u l=1u
X28 VGND.t27 analog_0 analog_1 VGND.t26 sg13_lv_nmos ad=0.19p pd=1.38u as=0.19p ps=1.38u w=1u l=1u
X29 VAPWR VAPWR VAPWR VAPWR sg13_lv_pmos ad=1.14p pd=6.38u as=0 ps=0 w=6u l=1u
X30 analog_2 ui_in[0].t1 VAPWR VAPWR sg13_lv_pmos ad=1.14p pd=6.38u as=1.14p ps=6.38u w=6u l=1u
X31 analog_2 ui_in[0].t1 VAPWR VAPWR sg13_lv_pmos ad=1.14p pd=6.38u as=1.14p ps=6.38u w=6u l=1u
X32 VAPWR VAPWR VAPWR VAPWR sg13_lv_pmos ad=2.04p pd=12.68u as=0 ps=0 w=6u l=1u
X33 VGND.t30 analog_0 analog_1 VGND.t29 sg13_lv_nmos ad=0.19p pd=1.38u as=0.19p ps=1.38u w=1u l=1u
X34 VAPWR analog_0 analog_1 VAPWR sg13_lv_pmos ad=1.14p pd=6.38u as=1.14p ps=6.38u w=6u l=1u
X35 analog_2 ui_in[0].t0 VGND.t48 VGND.t7 sg13_lv_nmos ad=0.19p pd=1.38u as=0.19p ps=1.38u w=1u l=1u
X36 VGND.t33 VGND.t45 VGND.t46 VGND.t39 sg13_lv_nmos ad=0.19p pd=1.38u as=0 ps=0 w=1u l=1u
X37 VGND.t0 VPWR VGND.t0 VGND.t0 sg13_lv_pmos ad=3.4p pd=20.68u as=0 ps=0 w=10u l=10u
X38 VGND.t52 ui_in[0].t0 analog_2 VGND.t11 sg13_lv_nmos ad=0.19p pd=1.38u as=0.19p ps=1.38u w=1u l=1u
X39 VGND.t6 analog_0 analog_1 VGND.t5 sg13_lv_nmos ad=0.19p pd=1.38u as=0.19p ps=1.38u w=1u l=1u
X40 VGND.t50 ui_in[0].t0 analog_2 VGND.t8 sg13_lv_nmos ad=0.19p pd=1.38u as=0.19p ps=1.38u w=1u l=1u
X41 VGND.t54 ui_in[0].t0 analog_2 VGND.t14 sg13_lv_nmos ad=0.19p pd=1.38u as=0.19p ps=1.38u w=1u l=1u
X42 analog_1 analog_0 VAPWR VAPWR sg13_lv_pmos ad=1.14p pd=6.38u as=1.14p ps=6.38u w=6u l=1u
X43 analog_1 analog_0 VAPWR VAPWR sg13_lv_pmos ad=1.14p pd=6.38u as=1.14p ps=6.38u w=6u l=1u
X44 VGND.t56 ui_in[0].t0 analog_2 VGND.t17 sg13_lv_nmos ad=0.19p pd=1.38u as=0.19p ps=1.38u w=1u l=1u
X45 analog_2 ui_in[0].t0 VGND.t60 VGND.t25 sg13_lv_nmos ad=0.19p pd=1.38u as=0.19p ps=1.38u w=1u l=1u
X46 analog_1 analog_0 VGND.t12 VGND.t13 sg13_lv_nmos ad=0.19p pd=1.38u as=0.19p ps=1.38u w=1u l=1u
X47 VAPWR analog_0 analog_1 VAPWR sg13_lv_pmos ad=1.14p pd=6.38u as=1.14p ps=6.38u w=6u l=1u
X48 analog_2 ui_in[0].t0 VGND.t58 VGND.t22 sg13_lv_nmos ad=0.19p pd=1.38u as=0.19p ps=1.38u w=1u l=1u
X49 analog_1 analog_0 VAPWR VAPWR sg13_lv_pmos ad=1.14p pd=6.38u as=1.14p ps=6.38u w=6u l=1u
X50 VGND.t62 ui_in[0].t0 analog_2 VGND.t26 sg13_lv_nmos ad=0.19p pd=1.38u as=0.19p ps=1.38u w=1u l=1u
X51 analog_1 analog_0 VGND.t15 VGND.t16 sg13_lv_nmos ad=0.19p pd=1.38u as=0.19p ps=1.38u w=1u l=1u
X52 VAPWR analog_0 analog_1 VAPWR sg13_lv_pmos ad=1.14p pd=6.38u as=1.14p ps=6.38u w=6u l=1u
X53 analog_1 analog_0 VAPWR VAPWR sg13_lv_pmos ad=1.14p pd=6.38u as=1.14p ps=6.38u w=6u l=1u
X54 VAPWR ui_in[0].t1 analog_2 VAPWR sg13_lv_pmos ad=1.14p pd=6.38u as=1.14p ps=6.38u w=6u l=1u
X55 VGND.t21 analog_0 analog_1 VGND.t20 sg13_lv_nmos ad=0.19p pd=1.38u as=0.19p ps=1.38u w=1u l=1u
X56 analog_1 analog_0 VAPWR VAPWR sg13_lv_pmos ad=1.14p pd=6.38u as=1.14p ps=6.38u w=6u l=1u
X57 analog_1 analog_0 VAPWR VAPWR sg13_lv_pmos ad=1.14p pd=6.38u as=1.14p ps=6.38u w=6u l=1u
X58 analog_2 ui_in[0].t1 VAPWR VAPWR sg13_lv_pmos ad=1.14p pd=6.38u as=1.14p ps=6.38u w=6u l=1u
X59 VGND.t64 ui_in[0].t0 analog_2 VGND.t29 sg13_lv_nmos ad=0.19p pd=1.38u as=0.19p ps=1.38u w=1u l=1u
X60 analog_1 analog_0 VGND.t18 VGND.t19 sg13_lv_nmos ad=0.19p pd=1.38u as=0.19p ps=1.38u w=1u l=1u
X61 VAPWR VAPWR VAPWR VAPWR sg13_lv_pmos ad=2.04p pd=12.68u as=0 ps=0 w=6u l=1u
X62 VGND.t41 VGND.t38 VGND.t40 VGND.t39 sg13_lv_nmos ad=0.19p pd=1.38u as=0 ps=0 w=1u l=1u
X63 VGND.t24 analog_0 analog_1 VGND.t23 sg13_lv_nmos ad=0.19p pd=1.38u as=0.19p ps=1.38u w=1u l=1u
X64 analog_1 analog_0 VGND.t30 VGND.t31 sg13_lv_nmos ad=0.19p pd=1.38u as=0.19p ps=1.38u w=1u l=1u
X65 VGND.t44 VGND.t42 VGND.t4 VGND.t35 sg13_lv_nmos ad=0.34p pd=2.68u as=0 ps=0 w=1u l=1u
X66 analog_1 analog_0 VGND.t9 VGND.t10 sg13_lv_nmos ad=0.19p pd=1.38u as=0.19p ps=1.38u w=1u l=1u
X67 analog_1 analog_0 VGND.t27 VGND.t28 sg13_lv_nmos ad=0.19p pd=1.38u as=0.19p ps=1.38u w=1u l=1u
X68 analog_2 ui_in[0].t1 VAPWR VAPWR sg13_lv_pmos ad=1.14p pd=6.38u as=1.14p ps=6.38u w=6u l=1u
X69 VAPWR ui_in[0].t1 analog_2 VAPWR sg13_lv_pmos ad=1.14p pd=6.38u as=1.14p ps=6.38u w=6u l=1u
X70 VGND.t48 ui_in[0].t0 analog_2 VGND.t5 sg13_lv_nmos ad=0.19p pd=1.38u as=0.19p ps=1.38u w=1u l=1u
X71 VAPWR ui_in[0].t1 analog_2 VAPWR sg13_lv_pmos ad=1.14p pd=6.38u as=1.14p ps=6.38u w=6u l=1u
X72 VAPWR ui_in[0].t1 analog_2 VAPWR sg13_lv_pmos ad=1.14p pd=6.38u as=1.14p ps=6.38u w=6u l=1u
X73 analog_2 ui_in[0].t0 VGND.t52 VGND.t13 sg13_lv_nmos ad=0.19p pd=1.38u as=0.19p ps=1.38u w=1u l=1u
X74 VAPWR ui_in[0].t1 analog_2 VAPWR sg13_lv_pmos ad=1.14p pd=6.38u as=1.14p ps=6.38u w=6u l=1u
X75 analog_2 ui_in[0].t1 VAPWR VAPWR sg13_lv_pmos ad=1.14p pd=6.38u as=1.14p ps=6.38u w=6u l=1u
X76 analog_2 ui_in[0].t0 VGND.t54 VGND.t16 sg13_lv_nmos ad=0.19p pd=1.38u as=0.19p ps=1.38u w=1u l=1u
X77 analog_2 ui_in[0].t1 VAPWR VAPWR sg13_lv_pmos ad=1.14p pd=6.38u as=1.14p ps=6.38u w=6u l=1u
X78 VGND.t58 ui_in[0].t0 analog_2 VGND.t20 sg13_lv_nmos ad=0.19p pd=1.38u as=0.19p ps=1.38u w=1u l=1u
X79 VAPWR analog_0 analog_1 VAPWR sg13_lv_pmos ad=1.14p pd=6.38u as=1.14p ps=6.38u w=6u l=1u
X80 VAPWR ui_in[0].t1 analog_2 VAPWR sg13_lv_pmos ad=1.14p pd=6.38u as=1.14p ps=6.38u w=6u l=1u
X81 analog_2 ui_in[0].t0 VGND.t56 VGND.t19 sg13_lv_nmos ad=0.19p pd=1.38u as=0.19p ps=1.38u w=1u l=1u
X82 analog_1 analog_0 VAPWR VAPWR sg13_lv_pmos ad=1.14p pd=6.38u as=1.14p ps=6.38u w=6u l=1u
X83 VGND.t60 ui_in[0].t0 analog_2 VGND.t23 sg13_lv_nmos ad=0.19p pd=1.38u as=0.19p ps=1.38u w=1u l=1u
X84 analog_2 ui_in[0].t0 VGND.t64 VGND.t31 sg13_lv_nmos ad=0.19p pd=1.38u as=0.19p ps=1.38u w=1u l=1u
X85 VGND.t2 VAPWR VGND.t2 VGND.t1 sg13_lv_pmos ad=3.4p pd=20.68u as=0 ps=0 w=10u l=10u
X86 VAPWR ui_in[0].t1 analog_2 VAPWR sg13_lv_pmos ad=1.14p pd=6.38u as=1.14p ps=6.38u w=6u l=1u
X87 analog_2 ui_in[0].t0 VGND.t50 VGND.t10 sg13_lv_nmos ad=0.19p pd=1.38u as=0.19p ps=1.38u w=1u l=1u
X88 analog_2 ui_in[0].t0 VGND.t62 VGND.t28 sg13_lv_nmos ad=0.19p pd=1.38u as=0.19p ps=1.38u w=1u l=1u
X89 VGND.t33 analog_0 analog_1 VGND.t32 sg13_lv_nmos ad=0.19p pd=1.38u as=0.19p ps=1.38u w=1u l=1u
R0 ui_in[0].n15 ui_in[0].t1 0.994683
R1 ui_in[0].n17 ui_in[0].t0 0.994013
R2 ui_in[0].n9 ui_in[0].n1 0.748572
R3 ui_in[0].n10 ui_in[0].n9 0.578786
R4 ui_in[0].n11 ui_in[0].n10 0.578786
R5 ui_in[0].n12 ui_in[0].n11 0.578786
R6 ui_in[0].n13 ui_in[0].n12 0.578786
R7 ui_in[0].n14 ui_in[0].n13 0.578786
R8 ui_in[0].n15 ui_in[0].n14 0.578786
R9 ui_in[0].n0 ui_in[0].n24 0.755676
R10 ui_in[0].n24 ui_in[0].n23 0.578786
R11 ui_in[0].n23 ui_in[0].n22 0.578786
R12 ui_in[0].n22 ui_in[0].n21 0.578786
R13 ui_in[0].n21 ui_in[0].n20 0.578786
R14 ui_in[0].n20 ui_in[0].n19 0.578786
R15 ui_in[0].n19 ui_in[0].n18 0.578786
R16 ui_in[0].n18 ui_in[0].n17 0.578786
R17 ui_in[0].n14 ui_in[0].n8 0.254024
R18 ui_in[0].n13 ui_in[0].n7 0.254024
R19 ui_in[0].n12 ui_in[0].n6 0.254024
R20 ui_in[0].n11 ui_in[0].n5 0.254024
R21 ui_in[0].n10 ui_in[0].n4 0.254024
R22 ui_in[0].n9 ui_in[0].n3 0.254024
R23 ui_in[0].n1 ui_in[0].n2 0.0282822
R24 ui_in[0].n24 ui_in[0].n2 0.254024
R25 ui_in[0].n23 ui_in[0].n3 0.254024
R26 ui_in[0].n22 ui_in[0].n4 0.254024
R27 ui_in[0].n21 ui_in[0].n5 0.254024
R28 ui_in[0].n20 ui_in[0].n6 0.254024
R29 ui_in[0].n19 ui_in[0].n7 0.254024
R30 ui_in[0].n18 ui_in[0].n8 0.254024
R31 ui_in[0].n17 ui_in[0].n16 0.192615
R32 ui_in[0].n16 ui_in[0].n15 0.191641
R33 ui_in[0].n16 ui_in[0].n8 0.128842
R34 ui_in[0].n1 ui_in[0].n0 0.105962
R35 ui_in[0].n3 ui_in[0].n2 0.12194
R36 ui_in[0].n4 ui_in[0].n3 0.12194
R37 ui_in[0].n5 ui_in[0].n4 0.12194
R38 ui_in[0].n6 ui_in[0].n5 0.12194
R39 ui_in[0].n7 ui_in[0].n6 0.12194
R40 ui_in[0].n8 ui_in[0].n7 0.12194
R41 ui_in[0] ui_in[0].n0 40.295
R42 VGND.n133 VGND.t3 86.957
R43 VGND.t32 VGND.n63 86.957
R44 VGND.n141 VGND.t5 81.5222
R45 VGND.t31 VGND.n65 81.5222
R46 VGND.n148 VGND.t7 76.0875
R47 VGND.t29 VGND.n69 76.0875
R48 VGND.n156 VGND.t8 70.6527
R49 VGND.t28 VGND.n71 70.6527
R50 VGND.n159 VGND.t10 65.2179
R51 VGND.t26 VGND.n75 65.2179
R52 VGND.n162 VGND.t11 59.7831
R53 VGND.t25 VGND.n76 59.7831
R54 VGND.n165 VGND.t13 54.3483
R55 VGND.t17 VGND.n90 54.3483
R56 VGND.n191 VGND.t19 54.3483
R57 VGND.t23 VGND.n78 54.3483
R58 VGND.n173 VGND.t14 48.9135
R59 VGND.t16 VGND.n95 48.9135
R60 VGND.n194 VGND.t20 48.9135
R61 VGND.t22 VGND.n81 48.9135
R62 VGND.t14 VGND.n97 43.4788
R63 VGND.n181 VGND.t16 43.4788
R64 VGND.t20 VGND.n83 43.4788
R65 VGND.n202 VGND.t22 43.4788
R66 VGND.t13 VGND.n99 38.044
R67 VGND.n184 VGND.t17 38.044
R68 VGND.t19 VGND.n88 38.044
R69 VGND.n208 VGND.t23 38.044
R70 VGND.t11 VGND.n106 32.6092
R71 VGND.n214 VGND.t25 32.6092
R72 VGND.t10 VGND.n111 27.1744
R73 VGND.n222 VGND.t26 27.1744
R74 VGND.t8 VGND.n117 21.7396
R75 VGND.n225 VGND.t28 21.7396
R76 VGND.n5 VGND.n6 1.17159
R77 VGND.n5 VGND.n59 17.0005
R78 VGND.n5 VGND.n10 0.661826
R79 VGND.n5 VGND.n248 17.0005
R80 VGND.n10 VGND.n245 14.3607
R81 VGND.n24 VGND.n243 14.36
R82 VGND.n5 VGND.n62 17.0005
R83 VGND.n5 VGND.n63 8.50053
R84 VGND.n5 VGND.n238 17.0005
R85 VGND.n15 VGND.n235 14.36
R86 VGND.n5 VGND.n21 0.661826
R87 VGND.n21 VGND.n232 14.3607
R88 VGND.n5 VGND.n68 17.0005
R89 VGND.n5 VGND.n69 8.49651
R90 VGND.n5 VGND.n227 17.0005
R91 VGND.n26 VGND.n224 14.3607
R92 VGND.n5 VGND.n14 0.661826
R93 VGND.n14 VGND.n221 14.36
R94 VGND.n5 VGND.n74 17.0005
R95 VGND.n5 VGND.n222 8.49953
R96 VGND.n18 VGND.n213 14.3607
R97 VGND.n5 VGND.n22 0.661826
R98 VGND.n5 VGND.n209 17.0005
R99 VGND.n22 VGND.n207 14.3607
R100 VGND.n5 VGND.n80 17.0005
R101 VGND.n16 VGND.n201 14.3607
R102 VGND.n5 VGND.n19 0.661826
R103 VGND.n5 VGND.n197 17.0005
R104 VGND.n19 VGND.n193 14.3607
R105 VGND.n12 VGND.n190 14.3607
R106 VGND.n5 VGND.n87 17.0005
R107 VGND.n5 VGND.n17 0.552335
R108 VGND.n5 VGND.n185 17.0005
R109 VGND.n17 VGND.n183 14.5797
R110 VGND.n11 VGND.n182 14.36
R111 VGND.n5 VGND.n11 0.661826
R112 VGND.n5 VGND.n94 17.0005
R113 VGND.n5 VGND.n95 8.49903
R114 VGND.n13 VGND.n176 14.36
R115 VGND.n5 VGND.n175 17.0005
R116 VGND.n5 VGND.n13 0.661826
R117 VGND.n5 VGND.n96 17.0005
R118 VGND.n5 VGND.n173 8.49915
R119 VGND.n25 VGND.n168 14.36
R120 VGND.n5 VGND.n167 17.0005
R121 VGND.n5 VGND.n25 0.661826
R122 VGND.n5 VGND.n9 0.661826
R123 VGND.n9 VGND.n161 14.3607
R124 VGND.n23 VGND.n160 14.36
R125 VGND.n5 VGND.n23 0.661826
R126 VGND.n5 VGND.n111 8.49602
R127 VGND.n8 VGND.n157 14.36
R128 VGND.n5 VGND.n8 0.661826
R129 VGND.n5 VGND.n116 17.0005
R130 VGND.n5 VGND.n117 8.49965
R131 VGND.n28 VGND.n151 14.36
R132 VGND.n5 VGND.n28 0.661826
R133 VGND.n5 VGND.n148 8.49952
R134 VGND.n27 VGND.n144 14.36
R135 VGND.n5 VGND.n143 17.0005
R136 VGND.n5 VGND.n27 0.661826
R137 VGND.n5 VGND.n119 17.0005
R138 VGND.n5 VGND.n120 8.49853
R139 VGND.n5 VGND.n135 17.0005
R140 VGND.n29 VGND.n132 14.36
R141 VGND.n5 VGND.n20 0.661826
R142 VGND.n20 VGND.n131 14.36
R143 VGND.n5 VGND.n7 0.661826
R144 VGND.n5 VGND.n126 17.0005
R145 VGND.n7 VGND.n130 14.3607
R146 VGND.n5 VGND.n31 17.0005
R147 VGND.n247 VGND.n3 17.0005
R148 VGND.n241 VGND.n3 17.0005
R149 VGND.n237 VGND.n3 17.0005
R150 VGND.n255 VGND.n3 17.0005
R151 VGND.n226 VGND.n3 17.0005
R152 VGND.n257 VGND.n3 17.0005
R153 VGND.n259 VGND.n3 17.0005
R154 VGND.n204 VGND.n3 17.0005
R155 VGND.n195 VGND.n3 17.0005
R156 VGND.n188 VGND.n3 17.0005
R157 VGND.n52 VGND.n3 17.0005
R158 VGND.n178 VGND.n3 17.0005
R159 VGND.n166 VGND.n3 17.0005
R160 VGND.n102 VGND.n3 17.0005
R161 VGND.n104 VGND.n3 17.0005
R162 VGND.n114 VGND.n3 17.0005
R163 VGND.n134 VGND.n3 17.0005
R164 VGND.n128 VGND.n3 17.0005
R165 VGND.n244 VGND.n5 8.49021
R166 VGND.n236 VGND.n5 8.4994
R167 VGND.n65 VGND.n5 8.49553
R168 VGND.n233 VGND.n5 8.49045
R169 VGND.n225 VGND.n5 8.49068
R170 VGND.n71 VGND.n5 8.49528
R171 VGND.n75 VGND.n5 8.49503
R172 VGND.n214 VGND.n5 8.49092
R173 VGND.n76 VGND.n5 8.49479
R174 VGND.n208 VGND.n5 8.49116
R175 VGND.n78 VGND.n5 8.49454
R176 VGND.n202 VGND.n5 8.4914
R177 VGND.n81 VGND.n5 8.4943
R178 VGND.n194 VGND.n5 8.49164
R179 VGND.n83 VGND.n5 8.49627
R180 VGND.n191 VGND.n5 8.49187
R181 VGND.n88 VGND.n5 8.49406
R182 VGND.n184 VGND.n5 8.49212
R183 VGND.n90 VGND.n5 8.49829
R184 VGND.n181 VGND.n5 8.49577
R185 VGND.n97 VGND.n5 8.49381
R186 VGND.n165 VGND.n5 8.49928
R187 VGND.n99 VGND.n5 8.49357
R188 VGND.n162 VGND.n5 8.49236
R189 VGND.n106 VGND.n5 8.49878
R190 VGND.n159 VGND.n5 8.4926
R191 VGND.n156 VGND.n5 8.49284
R192 VGND.n118 VGND.n5 8.49332
R193 VGND.n141 VGND.n5 8.49308
R194 VGND.n133 VGND.n5 8.49954
R195 VGND.t7 VGND.n118 16.3048
R196 VGND.n233 VGND.t29 16.3048
R197 VGND.t34 VGND.n58 15.0005
R198 VGND.t45 VGND.n267 15.0005
R199 VGND.n252 VGND.t38 15.0005
R200 VGND.n275 VGND.t42 15.0005
R201 VGND.t39 VGND.n10 7.18094
R202 VGND.n245 VGND.n24 14.3607
R203 VGND.n239 VGND.n15 14.3607
R204 VGND.n228 VGND.n26 14.3607
R205 VGND.n217 VGND.n18 14.3607
R206 VGND.n206 VGND.n16 14.3607
R207 VGND.n192 VGND.n12 14.3607
R208 VGND.n136 VGND.n29 14.3607
R209 VGND.n20 VGND.n122 7.18094
R210 VGND.n27 VGND.n140 14.3614
R211 VGND.n28 VGND.n147 14.3614
R212 VGND.n8 VGND.n155 14.3614
R213 VGND.n23 VGND.n158 14.3614
R214 VGND.n25 VGND.n164 14.3614
R215 VGND.n13 VGND.n172 14.3614
R216 VGND.n11 VGND.n180 14.3614
R217 VGND.t5 VGND.n120 10.8701
R218 VGND.n236 VGND.t31 10.8701
R219 VGND.n6 VGND.n3 0.0504289
R220 VGND.n122 VGND.n3 8.5005
R221 VGND.n5 VGND.n60 8.4984
R222 VGND.n5 VGND.n242 8.4984
R223 VGND.n5 VGND.n64 8.4984
R224 VGND.n5 VGND.n67 8.4984
R225 VGND.n5 VGND.n231 8.4984
R226 VGND.n5 VGND.n70 8.4984
R227 VGND.n5 VGND.n73 8.4984
R228 VGND.n5 VGND.n220 8.4984
R229 VGND.n5 VGND.n216 8.4984
R230 VGND.n5 VGND.n212 8.4984
R231 VGND.n5 VGND.n77 8.4984
R232 VGND.n5 VGND.n205 8.4984
R233 VGND.n5 VGND.n200 8.4984
R234 VGND.n5 VGND.n82 8.4984
R235 VGND.n5 VGND.n85 8.4984
R236 VGND.n5 VGND.n189 8.4984
R237 VGND.n5 VGND.n89 8.4984
R238 VGND.n5 VGND.n92 8.4984
R239 VGND.n5 VGND.n179 8.4984
R240 VGND.n5 VGND.n171 8.4984
R241 VGND.n5 VGND.n98 8.4984
R242 VGND.n5 VGND.n101 8.4984
R243 VGND.n5 VGND.n105 8.4984
R244 VGND.n5 VGND.n108 8.4984
R245 VGND.n5 VGND.n110 8.4984
R246 VGND.n5 VGND.n113 8.4984
R247 VGND.n5 VGND.n154 8.4984
R248 VGND.n5 VGND.n150 8.4984
R249 VGND.n5 VGND.n146 8.4984
R250 VGND.n5 VGND.n139 8.4984
R251 VGND.n5 VGND.n121 8.4984
R252 VGND.n5 VGND.n124 8.4984
R253 VGND.n5 VGND.n129 8.4984
R254 VGND.n246 VGND.n3 8.4984
R255 VGND.n61 VGND.n3 8.4984
R256 VGND.n240 VGND.n3 8.4984
R257 VGND.n66 VGND.n3 8.4984
R258 VGND.n230 VGND.n3 8.4984
R259 VGND.n229 VGND.n3 8.4984
R260 VGND.n72 VGND.n3 8.4984
R261 VGND.n219 VGND.n3 8.4984
R262 VGND.n218 VGND.n3 8.4984
R263 VGND.n215 VGND.n3 8.4984
R264 VGND.n211 VGND.n3 8.4984
R265 VGND.n79 VGND.n3 8.4984
R266 VGND.n203 VGND.n3 8.4984
R267 VGND.n199 VGND.n3 8.4984
R268 VGND.n84 VGND.n3 8.4984
R269 VGND.n86 VGND.n3 8.4984
R270 VGND.n187 VGND.n3 8.4984
R271 VGND.n91 VGND.n3 8.4984
R272 VGND.n93 VGND.n3 8.4984
R273 VGND.n177 VGND.n3 8.4984
R274 VGND.n170 VGND.n3 8.4984
R275 VGND.n169 VGND.n3 8.4984
R276 VGND.n100 VGND.n3 8.4984
R277 VGND.n107 VGND.n3 8.4984
R278 VGND.n109 VGND.n3 8.4984
R279 VGND.n112 VGND.n3 8.4984
R280 VGND.n153 VGND.n3 8.4984
R281 VGND.n152 VGND.n3 8.4984
R282 VGND.n149 VGND.n3 8.4984
R283 VGND.n145 VGND.n3 8.4984
R284 VGND.n138 VGND.n3 8.4984
R285 VGND.n137 VGND.n3 8.4984
R286 VGND.n123 VGND.n3 8.4984
R287 VGND.n125 VGND.n3 8.4984
R288 VGND.n127 VGND.n3 8.4984
R289 VGND.n272 VGND.t34 7.49606
R290 VGND.n268 VGND.t45 7.49606
R291 VGND.t38 VGND.n249 7.49606
R292 VGND.t42 VGND.n57 7.49606
R293 VGND.n239 VGND.n63 7.18094
R294 VGND.n234 VGND.n65 7.18094
R295 VGND.n228 VGND.n69 7.18094
R296 VGND.n217 VGND.n75 7.18094
R297 VGND.n206 VGND.n78 7.18094
R298 VGND.n192 VGND.n83 7.18094
R299 VGND.n182 VGND.n90 7.18094
R300 VGND.n176 VGND.n95 7.18094
R301 VGND.n168 VGND.n97 7.18094
R302 VGND.n160 VGND.n106 7.18094
R303 VGND.n157 VGND.n111 7.18094
R304 VGND.n151 VGND.n117 7.18094
R305 VGND.n144 VGND.n118 7.18094
R306 VGND.n136 VGND.n120 7.18094
R307 VGND.n131 VGND.n7 14.3614
R308 VGND.n133 VGND.n132 7.18094
R309 VGND.n9 VGND.n163 14.3614
R310 VGND.n17 VGND.n186 14.5804
R311 VGND.n19 VGND.n198 14.3614
R312 VGND.n22 VGND.n210 14.3614
R313 VGND.n222 VGND.n221 7.18094
R314 VGND.n14 VGND.n223 14.3614
R315 VGND.n236 VGND.n235 7.18094
R316 VGND.n244 VGND.n243 7.18094
R317 VGND.t39 VGND.n6 7.7674
R318 VGND.n21 VGND.n234 14.3607
R319 VGND.n233 VGND.n232 7.18026
R320 VGND.n225 VGND.n224 7.18026
R321 VGND.n214 VGND.n213 7.18026
R322 VGND.n208 VGND.n207 7.18026
R323 VGND.n202 VGND.n201 7.18026
R324 VGND.n194 VGND.n193 7.18026
R325 VGND.n191 VGND.n190 7.18026
R326 VGND.n184 VGND.n183 7.18026
R327 VGND.n181 VGND.n180 7.18026
R328 VGND.n173 VGND.n172 7.18026
R329 VGND.n165 VGND.n164 7.18026
R330 VGND.n162 VGND.n161 7.18026
R331 VGND.n159 VGND.n158 7.18026
R332 VGND.n156 VGND.n155 7.18026
R333 VGND.n148 VGND.n147 7.18026
R334 VGND.n141 VGND.n140 7.18026
R335 VGND.n130 VGND.t35 7.18026
R336 VGND.n223 VGND.n71 7.18026
R337 VGND.n210 VGND.n76 7.18026
R338 VGND.n198 VGND.n81 7.18026
R339 VGND.n186 VGND.n88 7.18026
R340 VGND.n163 VGND.n99 7.18026
R341 VGND.t3 VGND.n122 5.43528
R342 VGND.n244 VGND.t32 5.43528
R343 VGND.t4 VGND.n56 4.5005
R344 VGND.n273 VGND.t36 4.5005
R345 VGND.t33 VGND.n266 4.5005
R346 VGND.t41 VGND.n251 4.5005
R347 VGND.n3 VGND.n32 4.25219
R348 VGND.n5 VGND.n270 4.25206
R349 VGND.n270 VGND.n3 4.25175
R350 VGND.n5 VGND.n32 4.25169
R351 VGND.n277 VGND.n276 3.0005
R352 VGND.n271 VGND.n55 3.0005
R353 VGND.n265 VGND.n250 3.0005
R354 VGND.n254 VGND.n253 3.0005
R355 VGND.n279 VGND.t6 2.48177
R356 VGND.n280 VGND.t9 2.48177
R357 VGND.n281 VGND.t12 2.48177
R358 VGND.n54 VGND.t15 2.48177
R359 VGND.t21 VGND.n53 2.48177
R360 VGND.n261 VGND.t24 2.48177
R361 VGND.n262 VGND.t27 2.48177
R362 VGND.n263 VGND.t30 2.48177
R363 VGND.n279 VGND.t48 2.48177
R364 VGND.n280 VGND.t50 2.48177
R365 VGND.n281 VGND.t52 2.48177
R366 VGND.n54 VGND.t54 2.48177
R367 VGND.t58 VGND.n53 2.48177
R368 VGND.n261 VGND.t60 2.48177
R369 VGND.n262 VGND.t62 2.48177
R370 VGND.n263 VGND.t64 2.48177
R371 VGND.n24 VGND.n5 0.661826
R372 VGND.n15 VGND.n5 0.661826
R373 VGND.n26 VGND.n5 0.661826
R374 VGND.n18 VGND.n5 0.661826
R375 VGND.n16 VGND.n5 0.661826
R376 VGND.n12 VGND.n5 0.661826
R377 VGND.n29 VGND.n5 0.661826
R378 VGND.t35 VGND.n4 7.65325
R379 VGND.t44 VGND.n56 2.2505
R380 VGND.t37 VGND.n273 2.2505
R381 VGND.n266 VGND.t46 2.2505
R382 VGND.n251 VGND.t40 2.2505
R383 VGND VGND.n282 1.88203
R384 VGND.n282 VGND.n50 1.49725
R385 VGND.n282 VGND.n49 1.41932
R386 VGND.t46 VGND.n30 1.03826
R387 VGND.n243 VGND.n3 0.661826
R388 VGND.n239 VGND.n3 0.661826
R389 VGND.n235 VGND.n3 0.661826
R390 VGND.n228 VGND.n3 0.661826
R391 VGND.n223 VGND.n3 0.661826
R392 VGND.n221 VGND.n3 0.661826
R393 VGND.n213 VGND.n3 0.661826
R394 VGND.n210 VGND.n3 0.661826
R395 VGND.n206 VGND.n3 0.661826
R396 VGND.n201 VGND.n3 0.661826
R397 VGND.n198 VGND.n3 0.661826
R398 VGND.n192 VGND.n3 0.661826
R399 VGND.n190 VGND.n3 0.661826
R400 VGND.n186 VGND.n3 0.661826
R401 VGND.n180 VGND.n3 0.661826
R402 VGND.n172 VGND.n3 0.661826
R403 VGND.n163 VGND.n3 0.661826
R404 VGND.n158 VGND.n3 0.661826
R405 VGND.n157 VGND.n3 0.661826
R406 VGND.n155 VGND.n3 0.661826
R407 VGND.n151 VGND.n3 0.661826
R408 VGND.n144 VGND.n3 0.661826
R409 VGND.n140 VGND.n3 0.661826
R410 VGND.n136 VGND.n3 0.661826
R411 VGND.n132 VGND.n3 0.661826
R412 VGND.n131 VGND.n3 0.661826
R413 VGND.n4 VGND.n3 3.98777
R414 VGND.n5 VGND.n4 0.169399
R415 VGND.n245 VGND.n3 0.661826
R416 VGND.n234 VGND.n3 0.661826
R417 VGND.n232 VGND.n3 0.661826
R418 VGND.n224 VGND.n3 0.661826
R419 VGND.n217 VGND.n3 0.661826
R420 VGND.n207 VGND.n3 0.661826
R421 VGND.n193 VGND.n3 0.661826
R422 VGND.n183 VGND.n3 0.661826
R423 VGND.n182 VGND.n3 0.661826
R424 VGND.n176 VGND.n3 0.661826
R425 VGND.n168 VGND.n3 0.661826
R426 VGND.n164 VGND.n3 0.661826
R427 VGND.n161 VGND.n3 0.661826
R428 VGND.n160 VGND.n3 0.661826
R429 VGND.n147 VGND.n3 0.661826
R430 VGND.n130 VGND.n3 0.661826
R431 VGND.n36 VGND.t2 0.412464
R432 VGND.n48 VGND.n47 0.41245
R433 VGND.n41 VGND.n40 0.409591
R434 VGND.n43 VGND.n42 0.409591
R435 VGND.n45 VGND.n44 0.409591
R436 VGND.n46 VGND.n35 0.409591
R437 VGND.n0 VGND.n1 0.0613672
R438 VGND.n40 VGND.n2 0.409591
R439 VGND.n43 VGND.n39 0.409591
R440 VGND.n45 VGND.n38 0.409591
R441 VGND.n46 VGND.n37 0.409591
R442 VGND.n47 VGND.n36 0.409591
R443 VGND.t2 VGND.t1 0.761345
R444 VGND.n49 VGND.n1 0.382149
R445 VGND.n49 VGND.n33 0.204366
R446 VGND.n49 VGND.n34 0.204366
R447 VGND.n49 VGND.n48 0.204366
R448 VGND.n142 VGND.t48 0.200997
R449 VGND.n115 VGND.t50 0.200997
R450 VGND.n103 VGND.t52 0.200997
R451 VGND.n174 VGND.t54 0.200997
R452 VGND.n196 VGND.t58 0.200997
R453 VGND.t60 VGND.n260 0.200997
R454 VGND.t62 VGND.n258 0.200997
R455 VGND.t64 VGND.n256 0.200997
R456 VGND.n142 VGND.t6 0.200995
R457 VGND.n115 VGND.t9 0.200995
R458 VGND.n103 VGND.t12 0.200995
R459 VGND.n174 VGND.t15 0.200995
R460 VGND.n196 VGND.t21 0.200995
R461 VGND.n260 VGND.t24 0.200995
R462 VGND.n258 VGND.t27 0.200995
R463 VGND.n256 VGND.t30 0.200995
R464 VGND.n51 VGND.t18 0.185126
R465 VGND.t37 VGND.n5 1.05625
R466 VGND.n279 VGND.n278 0.117247
R467 VGND.n264 VGND.n263 0.1171
R468 VGND.n280 VGND.n279 0.08146
R469 VGND.n281 VGND.n280 0.08146
R470 VGND.n54 VGND.n281 0.08146
R471 VGND.n50 VGND.n54 0.08146
R472 VGND.n50 VGND.n53 0.08146
R473 VGND.n261 VGND.n53 0.08146
R474 VGND.n262 VGND.n261 0.08146
R475 VGND.n263 VGND.n262 0.08146
R476 VGND.t36 VGND.n272 0.031258
R477 VGND.n57 VGND.t4 0.031258
R478 VGND.n278 VGND.n277 0.0291125
R479 VGND.n278 VGND.n55 0.0291125
R480 VGND.n264 VGND.n254 0.0291125
R481 VGND.n265 VGND.n264 0.0291125
R482 VGND.n277 VGND.n56 0.0281144
R483 VGND.n273 VGND.n55 0.0281144
R484 VGND.n254 VGND.n251 0.0281144
R485 VGND.n266 VGND.n265 0.0281144
R486 VGND.n269 VGND.n268 0.0216549
R487 VGND.n269 VGND.n249 0.0216549
R488 VGND.n267 VGND.t33 0.0208704
R489 VGND.n252 VGND.t41 0.0208704
R490 VGND.n271 VGND.n58 0.0202884
R491 VGND.n267 VGND.n250 0.0202884
R492 VGND.n253 VGND.n252 0.0202884
R493 VGND.n276 VGND.n275 0.0202884
R494 VGND.n51 VGND.n50 0.0194533
R495 VGND.n270 VGND.n269 0.0162424
R496 VGND.n274 VGND.n32 0.0159649
R497 VGND.n61 VGND.n60 0.0118857
R498 VGND.n242 VGND.n240 0.0118857
R499 VGND.n66 VGND.n64 0.0118857
R500 VGND.n231 VGND.n229 0.0118857
R501 VGND.n72 VGND.n70 0.0118857
R502 VGND.n218 VGND.n216 0.0118857
R503 VGND.n215 VGND.n212 0.0118857
R504 VGND.n212 VGND.n211 0.0118857
R505 VGND.n79 VGND.n77 0.0118857
R506 VGND.n205 VGND.n203 0.0118857
R507 VGND.n200 VGND.n199 0.0118857
R508 VGND.n84 VGND.n82 0.0118857
R509 VGND.n189 VGND.n187 0.0118857
R510 VGND.n91 VGND.n89 0.0118857
R511 VGND.n93 VGND.n92 0.0118857
R512 VGND.n179 VGND.n177 0.0118857
R513 VGND.n171 VGND.n170 0.0118857
R514 VGND.n171 VGND.n169 0.0118857
R515 VGND.n100 VGND.n98 0.0118857
R516 VGND.n107 VGND.n105 0.0118857
R517 VGND.n109 VGND.n108 0.0118857
R518 VGND.n112 VGND.n110 0.0118857
R519 VGND.n154 VGND.n152 0.0118857
R520 VGND.n149 VGND.n146 0.0118857
R521 VGND.n146 VGND.n145 0.0118857
R522 VGND.n139 VGND.n137 0.0118857
R523 VGND.n123 VGND.n121 0.0118857
R524 VGND.n129 VGND.n127 0.0118857
R525 VGND.n125 VGND.n124 0.0118857
R526 VGND.n124 VGND.n123 0.0118857
R527 VGND.n139 VGND.n138 0.0118857
R528 VGND.n150 VGND.n149 0.0118857
R529 VGND.n152 VGND.n150 0.0118857
R530 VGND.n154 VGND.n153 0.0118857
R531 VGND.n113 VGND.n112 0.0118857
R532 VGND.n110 VGND.n109 0.0118857
R533 VGND.n108 VGND.n107 0.0118857
R534 VGND.n101 VGND.n100 0.0118857
R535 VGND.n92 VGND.n91 0.0118857
R536 VGND.n86 VGND.n85 0.0118857
R537 VGND.n85 VGND.n84 0.0118857
R538 VGND.n203 VGND.n200 0.0118857
R539 VGND.n216 VGND.n215 0.0118857
R540 VGND.n220 VGND.n218 0.0118857
R541 VGND.n220 VGND.n219 0.0118857
R542 VGND.n73 VGND.n72 0.0118857
R543 VGND.n231 VGND.n230 0.0118857
R544 VGND.n67 VGND.n66 0.0118857
R545 VGND.n274 VGND.n58 0.0115582
R546 VGND.n275 VGND.n274 0.0115582
R547 VGND.n128 VGND.n126 0.0108889
R548 VGND.n135 VGND.n134 0.0108889
R549 VGND.n167 VGND.n166 0.0108889
R550 VGND.n178 VGND.n94 0.0108889
R551 VGND.n188 VGND.n87 0.0108889
R552 VGND.n204 VGND.n80 0.0108889
R553 VGND.n227 VGND.n226 0.0108889
R554 VGND.n238 VGND.n237 0.0108889
R555 VGND.n241 VGND.n62 0.0108889
R556 VGND.n248 VGND.n247 0.0108889
R557 VGND.n272 VGND.n271 0.0108877
R558 VGND.n268 VGND.n250 0.0108877
R559 VGND.n253 VGND.n249 0.0108877
R560 VGND.n276 VGND.n57 0.0108877
R561 VGND.n269 VGND.t46 0.0101032
R562 VGND.n269 VGND.t40 0.0101032
R563 VGND.n274 VGND.t37 0.00981217
R564 VGND.n274 VGND.t44 0.00981217
R565 VGND.n143 VGND.n142 0.00936111
R566 VGND.n256 VGND.n68 0.00936111
R567 VGND.n115 VGND.n114 0.00813889
R568 VGND.n258 VGND.n74 0.00813889
R569 VGND.n103 VGND.n102 0.00691667
R570 VGND.t56 VGND.n52 0.00691667
R571 VGND.n185 VGND.t56 0.00691667
R572 VGND.n260 VGND.n259 0.00691667
R573 VGND.t0 VGND.n2 0.00643258
R574 VGND.n2 VGND.n39 0.00643258
R575 VGND.n39 VGND.n38 0.00643258
R576 VGND.n38 VGND.n37 0.00643258
R577 VGND.n37 VGND.n36 0.00643258
R578 VGND.n274 VGND.n31 0.00630556
R579 VGND.n255 VGND.n67 0.00619286
R580 VGND.n257 VGND.n73 0.00619286
R581 VGND.n102 VGND.n101 0.00619286
R582 VGND.n114 VGND.n113 0.00619286
R583 VGND.n246 VGND.n59 0.00619286
R584 VGND.n230 VGND.n68 0.00619286
R585 VGND.n219 VGND.n74 0.00619286
R586 VGND.n87 VGND.n86 0.00619286
R587 VGND.n153 VGND.n116 0.00619286
R588 VGND.n138 VGND.n119 0.00619286
R589 VGND.n126 VGND.n125 0.00619286
R590 VGND.n127 VGND.n31 0.00619286
R591 VGND.n129 VGND.n128 0.00619286
R592 VGND.n134 VGND.n121 0.00619286
R593 VGND.n137 VGND.n135 0.00619286
R594 VGND.n145 VGND.n143 0.00619286
R595 VGND.n105 VGND.n104 0.00619286
R596 VGND.n166 VGND.n98 0.00619286
R597 VGND.n169 VGND.n167 0.00619286
R598 VGND.n170 VGND.n96 0.00619286
R599 VGND.n177 VGND.n175 0.00619286
R600 VGND.n179 VGND.n178 0.00619286
R601 VGND.n94 VGND.n93 0.00619286
R602 VGND.n52 VGND.n89 0.00619286
R603 VGND.n187 VGND.n185 0.00619286
R604 VGND.n189 VGND.n188 0.00619286
R605 VGND.n195 VGND.n82 0.00619286
R606 VGND.n199 VGND.n197 0.00619286
R607 VGND.n205 VGND.n204 0.00619286
R608 VGND.n80 VGND.n79 0.00619286
R609 VGND.n259 VGND.n77 0.00619286
R610 VGND.n211 VGND.n209 0.00619286
R611 VGND.n226 VGND.n70 0.00619286
R612 VGND.n229 VGND.n227 0.00619286
R613 VGND.n237 VGND.n64 0.00619286
R614 VGND.n240 VGND.n238 0.00619286
R615 VGND.n242 VGND.n241 0.00619286
R616 VGND.n62 VGND.n61 0.00619286
R617 VGND.n247 VGND.n60 0.00619286
R618 VGND.n248 VGND.n246 0.00619286
R619 VGND.n269 VGND.n59 0.00615278
R620 VGND.n174 VGND.n96 0.00569444
R621 VGND.n175 VGND.n174 0.00569444
R622 VGND.n196 VGND.n195 0.00569444
R623 VGND.n197 VGND.n196 0.00569444
R624 VGND.n33 VGND.n0 0.00851061
R625 VGND.n42 VGND.n41 0.00524607
R626 VGND.n44 VGND.n35 0.00524607
R627 VGND.t0 VGND.n1 0.0609359
R628 VGND.n40 VGND.n0 0.00926624
R629 VGND.n43 VGND.n40 0.00524607
R630 VGND.n45 VGND.n43 0.00524607
R631 VGND.n46 VGND.n45 0.00524607
R632 VGND.n47 VGND.n46 0.00524607
R633 VGND.n104 VGND.n103 0.00447222
R634 VGND.n260 VGND.n209 0.00447222
R635 VGND.n5 VGND.t40 1.02879
R636 VGND.n42 VGND.n34 0.00335935
R637 VGND.n48 VGND.n35 0.00335935
R638 VGND.n41 VGND.n33 0.00335935
R639 VGND.n44 VGND.n34 0.00335935
R640 VGND.n116 VGND.n115 0.00325
R641 VGND.n258 VGND.n257 0.00325
R642 VGND.n30 VGND.n3 0.00362128
R643 VGND.t56 VGND.n51 0.00249109
R644 VGND.n142 VGND.n119 0.00202778
R645 VGND.n256 VGND.n255 0.00202778
R646 VGND.t44 VGND.n30 1.08145
C0 ui_in[0] analog_0 0.25462f
C1 analog_1 analog_0 19.9607f
C2 VAPWR analog_2 19.494f
C3 ui_in[0] VPWR 0.54099f
C4 VAPWR analog_0 30.2344f
C5 ui_in[0] analog_2 18.7529f
C6 VAPWR ui_in[0] 30.2796f
C7 analog_1 analog_2 1.44271f
C8 VAPWR analog_1 19.588f
C9 uo_out[0] VGND 0.04448f
C10 uo_out[1] VGND 0.03799f
C11 uo_out[2] VGND 0.03799f
C12 uo_out[3] VGND 0.03799f
C13 uo_out[4] VGND 0.03799f
C14 uo_out[5] VGND 0.03799f
C15 uo_out[6] VGND 0.03799f
C16 uo_out[7] VGND 0.03799f
C17 uio_out[0] VGND 0.03799f
C18 uio_out[1] VGND 0.03799f
C19 uio_out[2] VGND 0.03799f
C20 uio_out[3] VGND 0.03799f
C21 uio_out[4] VGND 0.03799f
C22 uio_out[5] VGND 0.03799f
C23 uio_out[6] VGND 0.03799f
C24 uio_out[7] VGND 0.03799f
C25 uio_oe[0] VGND 0.03799f
C26 uio_oe[1] VGND 0.03799f
C27 uio_oe[2] VGND 0.03799f
C28 uio_oe[3] VGND 0.03799f
C29 uio_oe[4] VGND 0.03799f
C30 uio_oe[5] VGND 0.03799f
C31 uio_oe[6] VGND 0.03799f
C32 uio_oe[7] VGND 0.03799f
C33 ui_in[1] VGND 0.03799f
C34 ui_in[2] VGND 0.03799f
C35 ui_in[3] VGND 0.03799f
C36 ui_in[4] VGND 0.03799f
C37 ui_in[5] VGND 0.03799f
C38 ui_in[6] VGND 0.03799f
C39 ui_in[7] VGND 0.03799f
C40 uio_in[0] VGND 0.03799f
C41 uio_in[1] VGND 0.03799f
C42 uio_in[2] VGND 0.03799f
C43 uio_in[3] VGND 0.03799f
C44 uio_in[4] VGND 0.03799f
C45 uio_in[5] VGND 0.03799f
C46 uio_in[6] VGND 0.03799f
C47 uio_in[7] VGND 0.03799f
C48 ena VGND 0.03799f
C49 clk VGND 0.03799f
C50 rst_n VGND 0.04448f
C51 analog_1 VGND 27.9707f
C52 analog_2 VGND 33.2753f
C53 ui_in[0] VGND 32.20408f
C54 VGND.t0 VGND 50.5974f
C55 VGND.t4 VGND 13.1891f
C56 VGND.t41 VGND 3.54405f
C57 ui_in[0].n0 VGND 4.60807f
C58 ui_in[0].n1 VGND 0.13896f
C59 ui_in[0].n2 VGND 0.26857f
C60 ui_in[0].n3 VGND 0.26857f
C61 ui_in[0].n4 VGND 0.26857f
C62 ui_in[0].n5 VGND 0.26857f
C63 ui_in[0].n6 VGND 0.26857f
C64 ui_in[0].n7 VGND 0.26857f
C65 ui_in[0].n8 VGND 0.28384f
C66 ui_in[0].n9 VGND 0.08166f
C67 ui_in[0].n10 VGND 0.06297f
C68 ui_in[0].n11 VGND 0.06297f
C69 ui_in[0].n12 VGND 0.06297f
C70 ui_in[0].n13 VGND 0.06297f
C71 ui_in[0].n14 VGND 0.06297f
C72 ui_in[0].n15 VGND 0.70263f
C73 ui_in[0].n16 VGND 2.82525f
C74 ui_in[0].n17 VGND 0.71398f
C75 ui_in[0].n18 VGND 0.06297f
C76 ui_in[0].n19 VGND 0.06297f
C77 ui_in[0].n20 VGND 0.06297f
C78 ui_in[0].n21 VGND 0.06297f
C79 ui_in[0].n22 VGND 0.06297f
C80 ui_in[0].n23 VGND 0.06297f
C81 ui_in[0].n24 VGND 0.08251f
.ends
