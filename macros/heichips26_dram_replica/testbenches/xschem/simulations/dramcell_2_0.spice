** sch_path: /home/bah67de/git/heichips26_dram_replica/macros/heichips26_analog_project/macros/dramcell_2_0/schematic/xschem/dramcell_2_0.sch
.SUBCKT dramcell_2_0 WWL WBL RWL RBL VGND NodeC
*.PININFO RBL:O WWL:I WBL:I RWL:I VGND:B NodeC:B
MM4 WBL WWL NodeC VGND sg13_lv_nmos w=0.3u l=0.13u ng=1
MM5 net1 NodeC VGND VGND sg13_lv_nmos w=0.3u l=0.13u ng=1
MM6 RBL RWL net1 VGND sg13_lv_nmos w=0.9u l=0.13u ng=3
*connector(6,1) ?1 VGND ?1 WWL ?1 WBL ?1 RWL ?1 RBL ?1 NodeC
.ENDS
