* Extracted by KLayout with SG13CMOS5L LVS runset on : 19/08/2026 18:56

.SUBCKT dramcell_2_0 NodeC RBL RWL VGND WBL WWL
M$1 WBL WWL NodeC VGND sg13_lv_nmos L=0.13u W=0.3u AS=0.102p AD=0.102p PS=1.28u
+ PD=1.28u rfmode=0
M$2 VGND NodeC \$6 VGND sg13_lv_nmos L=0.13u W=0.3u AS=0.102p AD=0.057p
+ PS=1.28u PD=0.68u rfmode=0
M$3 \$6 RWL RBL VGND sg13_lv_nmos L=0.13u W=0.9u AS=0.171p AD=0.216p PS=2.04u
+ PD=2.64u rfmode=0
.ENDS dramcell_2_0
